* NGSPICE file created from relax_oscillator_tb.ext - technology: sky130A

.subckt relax_oscillator_tb Vdd out rst_rc Bit5 Bit4 Bit3 Bit2 Bit1 Bit0 gnd
X0 x5.sky130_fd_pr__cap_mim_m3_2_SLGBQV_2.C2.t0 Bit4.t0 gnd.t59 gnd.t58 sky130_fd_pr__nfet_01v8 ad=3.045 pd=21.58 as=3.045 ps=21.58 w=10.5 l=0.15
X1 x3.XM5.S x3.XM3.S gnd.t79 gnd.t78 sky130_fd_pr__nfet_01v8 ad=0.29 pd=2.58 as=0.29 ps=2.58 w=1 l=0.75
X2 x3.XM9.S x3.XM7.S gnd.t45 gnd.t44 sky130_fd_pr__nfet_01v8 ad=0.29 pd=2.58 as=0.29 ps=2.58 w=1 l=0.75
X3 x2.XM3.S x2.XM1.S gnd.t72 gnd.t71 sky130_fd_pr__nfet_01v8 ad=0.29 pd=2.58 as=0.29 ps=2.58 w=1 l=0.75
X4 x5.Phi_1.t1 x5.Phi_2.t3 Vdd.t51 Vdd.t50 sky130_fd_pr__pfet_01v8 ad=0.435 pd=3.58 as=0.435 ps=3.58 w=1.5 l=0.15
X5 x1.XM3.S x5.Vplus.t4 x1.XM3.D.t0 gnd.t56 sky130_fd_pr__nfet_01v8 ad=1.0875 pd=8.08 as=1.0875 ps=8.08 w=3.75 l=0.75
X6 gnd.t69 rst_rc.t0 x5.Vplus.t3 gnd.t68 sky130_fd_pr__nfet_01v8 ad=3.045 pd=21.58 as=3.045 ps=21.58 w=10.5 l=0.15
X7 x5.XM13.S Bit5.t0 x5.sky130_fd_pr__cap_mim_m3_2_SLGBQV_8.C2.t0 gnd.t83 sky130_fd_pr__nfet_01v8 ad=3.045 pd=21.58 as=3.045 ps=21.58 w=10.5 l=0.15
X8 x2.XM7.S x2.XM5.S Vdd.t37 Vdd.t36 sky130_fd_pr__pfet_01v8 ad=0.58 pd=4.58 as=0.58 ps=4.58 w=2 l=0.75
X9 x5.Vminus.t3 x5.XC16.C2 sky130_fd_pr__cap_mim_m3_2 l=15 w=26.15
X10 out.t2 x2.in.t2 Vdd.t33 Vdd.t32 sky130_fd_pr__pfet_01v8 ad=0.87 pd=6.58 as=0.87 ps=6.58 w=3 l=0.15
X11 x3.XM1.S out.t3 gnd.t63 gnd.t62 sky130_fd_pr__nfet_01v8 ad=0.29 pd=2.58 as=0.29 ps=2.58 w=1 l=0.15
X12 x5.sky130_fd_pr__res_xhigh_po_0p35_CBQ445_2.R1_1 x5.sky130_fd_pr__res_xhigh_po_0p35_CBQ445_2.R2_0 gnd.t47 sky130_fd_pr__res_xhigh_po_0p35 l=24.92
X13 x5.Vplus.t2 x5.sky130_fd_pr__res_xhigh_po_0p35_CBQ445_0.R2_0 gnd.t61 sky130_fd_pr__res_xhigh_po_0p35 l=24.92
X14 x5.XM11.S Bit3.t0 x5.XC16.C2.t0 gnd.t84 sky130_fd_pr__nfet_01v8 ad=3.045 pd=21.58 as=3.045 ps=21.58 w=10.5 l=0.15
X15 x5.Vplus.t5 x5.XC2.C2 sky130_fd_pr__cap_mim_m3_2 l=15 w=6.4
X16 x5.Vplus.t6 x5.sky130_fd_pr__cap_mim_m3_2_SLGBQV_5.C2.t3 sky130_fd_pr__cap_mim_m3_2 l=15 w=26.15
X17 x5.XM8.S Bit2.t0 x5.XC15.C2.t0 gnd.t12 sky130_fd_pr__nfet_01v8 ad=3.045 pd=21.58 as=3.045 ps=21.58 w=10.5 l=0.15
X18 x5.sky130_fd_pr__pfet_01v8_YRFZ7K_0.S.t1 x5.XM20.G Vdd.t21 Vdd.t20 sky130_fd_pr__pfet_01v8 ad=5.568 pd=38.98 as=5.568 ps=38.98 w=19.2 l=0.15
X19 gnd.t39 x5.Phi_2.t4 x5.sky130_fd_pr__res_xhigh_po_0p35_CBQ445_1.R1_2 gnd.t38 sky130_fd_pr__nfet_01v8 ad=3.045 pd=21.58 as=3.045 ps=21.58 w=10.5 l=0.15
X20 x3.XM3.S x3.XM1.S Vdd.t17 Vdd.t16 sky130_fd_pr__pfet_01v8 ad=0.58 pd=4.58 as=0.58 ps=4.58 w=2 l=0.75
X21 x5.sky130_fd_pr__pfet_01v8_YRFZ7K_0.S.t0 x5.sky130_fd_pr__res_xhigh_po_0p35_CBQ445_3.R2_1 gnd.t35 sky130_fd_pr__res_xhigh_po_0p35 l=24.92
X22 x5.sky130_fd_pr__cap_mim_m3_2_SLGBQV_0.C2.t0 Bit3.t1 gnd.t29 gnd.t28 sky130_fd_pr__nfet_01v8 ad=3.045 pd=21.58 as=3.045 ps=21.58 w=10.5 l=0.15
X23 gnd.t6 x2.in.t3 x2.XM13.S gnd.t5 sky130_fd_pr__nfet_01v8 ad=0.29 pd=2.58 as=0.29 ps=2.58 w=1 l=0.75
X24 Vdd.t1 x1.XM11.D.t1 x1.XM11.D.t2 Vdd.t0 sky130_fd_pr__pfet_01v8 ad=2.175 pd=15.58 as=2.175 ps=15.58 w=7.5 l=0.75
X25 x5.Vminus.t4 x5.XC5.C2 sky130_fd_pr__cap_mim_m3_2 l=15 w=26.15
X26 x4.Rst.t1 x2.XM9.S Vdd.t3 Vdd.t2 sky130_fd_pr__pfet_01v8 ad=0.58 pd=4.58 as=0.58 ps=4.58 w=2 l=0.75
X27 x2.XM5.S x2.XM3.S gnd.t74 gnd.t73 sky130_fd_pr__nfet_01v8 ad=0.29 pd=2.58 as=0.29 ps=2.58 w=1 l=0.75
X28 x2.XM9.S x2.XM7.S gnd.t67 gnd.t66 sky130_fd_pr__nfet_01v8 ad=0.29 pd=2.58 as=0.29 ps=2.58 w=1 l=0.75
X29 x1.XM4.S x5.Vminus.t5 x1.XM3.S gnd.t0 sky130_fd_pr__nfet_01v8 ad=1.0875 pd=8.08 as=1.0875 ps=8.08 w=3.75 l=0.75
X30 x5.Vminus.t6 x5.XC15.C2 sky130_fd_pr__cap_mim_m3_2 l=15 w=13
X31 Vdd.t13 x5.Phi_1.t3 x5.Phi_2.t1 Vdd.t12 sky130_fd_pr__pfet_01v8 ad=0.435 pd=3.58 as=0.435 ps=3.58 w=1.5 l=0.15
X32 Vdd.t57 out.t4 x4.Set Vdd.t56 sky130_fd_pr__pfet_01v8 ad=0.58 pd=4.58 as=0.58 ps=4.58 w=2 l=0.75
X33 x5.sky130_fd_pr__res_xhigh_po_0p35_CBQ445_1.R1_0 x5.Vminus.t2 gnd.t60 sky130_fd_pr__res_xhigh_po_0p35 l=24.92
X34 x5.Vplus.t7 x5.XC1.C2 sky130_fd_pr__cap_mim_m3_2 l=15 w=3.11
X35 x5.Vminus.t7 x5.XC5.C2 sky130_fd_pr__cap_mim_m3_2 l=15 w=26.15
X36 Vdd.t5 rst_rc.t1 x5.XM20.G Vdd.t4 sky130_fd_pr__pfet_01v8 ad=0.58 pd=4.58 as=0.58 ps=4.58 w=2 l=0.15
X37 x5.Vplus.t8 x5.sky130_fd_pr__cap_mim_m3_2_SLGBQV_5.C2.t2 sky130_fd_pr__cap_mim_m3_2 l=15 w=26.15
X38 x2.XM1.S x2.in.t4 gnd.t20 gnd.t19 sky130_fd_pr__nfet_01v8 ad=0.29 pd=2.58 as=0.29 ps=2.58 w=1 l=0.15
X39 x2.in.t1 x1.XM4.S Vdd.t35 Vdd.t34 sky130_fd_pr__pfet_01v8 ad=0.435 pd=3.58 as=0.435 ps=3.58 w=1.5 l=0.15
X40 x5.Vplus.t9 x5.sky130_fd_pr__cap_mim_m3_2_SLGBQV_2.C2 sky130_fd_pr__cap_mim_m3_2 l=15 w=26.15
X41 x5.Vplus.t10 x5.sky130_fd_pr__cap_mim_m3_2_SLGBQV_5.C2.t2 sky130_fd_pr__cap_mim_m3_2 l=15 w=26.15
X42 x3.XM5.S x3.XM3.S Vdd.t55 Vdd.t54 sky130_fd_pr__pfet_01v8 ad=0.58 pd=4.58 as=0.58 ps=4.58 w=2 l=0.75
X43 x1.XM9.G x1.XM9.G gnd.t34 gnd.t33 sky130_fd_pr__nfet_01v8 ad=0.203 pd=1.98 as=0.203 ps=1.98 w=0.7 l=0.75
X44 x3.XM9.S x3.XM7.S Vdd.t29 Vdd.t28 sky130_fd_pr__pfet_01v8 ad=0.58 pd=4.58 as=0.58 ps=4.58 w=2 l=0.75
X45 x5.Phi_2.t0 x5.Phi_1.t4 x4.XM6.S gnd.t8 sky130_fd_pr__nfet_01v8 ad=0.2175 pd=2.08 as=0.2175 ps=2.08 w=0.75 l=0.15
X46 x5.sky130_fd_pr__res_xhigh_po_0p35_CBQ445_2.R1_1 x5.sky130_fd_pr__res_xhigh_po_0p35_CBQ445_2.R2_2.t0 gnd.t25 sky130_fd_pr__res_xhigh_po_0p35 l=24.92
X47 gnd.t10 x5.Phi_1.t5 x5.sky130_fd_pr__res_xhigh_po_0p35_CBQ445_0.R2_2 gnd.t9 sky130_fd_pr__nfet_01v8 ad=3.045 pd=21.58 as=3.045 ps=21.58 w=10.5 l=0.15
X48 Vdd.t49 x5.Phi_2.t5 x5.sky130_fd_pr__pfet_01v8_YRFZ7K_0.S.t2 Vdd.t48 sky130_fd_pr__pfet_01v8 ad=5.568 pd=38.98 as=5.568 ps=38.98 w=19.2 l=0.15
X49 x5.Vplus.t11 x5.sky130_fd_pr__cap_mim_m3_2_SLGBQV_2.C2 sky130_fd_pr__cap_mim_m3_2 l=15 w=26.15
X50 x3.XM7.S x3.XM5.S gnd.t24 gnd.t23 sky130_fd_pr__nfet_01v8 ad=0.29 pd=2.58 as=0.29 ps=2.58 w=1 l=0.75
X51 x3.XM1.S out.t5 Vdd.t7 Vdd.t6 sky130_fd_pr__pfet_01v8 ad=0.58 pd=4.58 as=0.58 ps=4.58 w=2 l=0.15
X52 x2.in.t0 x1.XM4.S gnd.t53 gnd.t52 sky130_fd_pr__nfet_01v8 ad=0.2175 pd=2.08 as=0.2175 ps=2.08 w=0.75 l=0.15
X53 x2.XM3.S x2.XM1.S Vdd.t47 Vdd.t46 sky130_fd_pr__pfet_01v8 ad=0.58 pd=4.58 as=0.58 ps=4.58 w=2 l=0.75
X54 x5.XC2.C2.t0 Bit1.t0 gnd.t49 gnd.t48 sky130_fd_pr__nfet_01v8 ad=3.045 pd=21.58 as=3.045 ps=21.58 w=10.5 l=0.15
X55 x5.Vminus.t8 x5.XC13.C2 sky130_fd_pr__cap_mim_m3_2 l=15 w=3.11
X56 x5.Vminus.t9 x5.sky130_fd_pr__cap_mim_m3_2_SLGBQV_8.C2.t2 sky130_fd_pr__cap_mim_m3_2 l=15 w=26.15
X57 x5.sky130_fd_pr__res_xhigh_po_0p35_CBQ445_3.R1_0 x5.sky130_fd_pr__res_xhigh_po_0p35_CBQ445_3.R2_1 gnd.t7 sky130_fd_pr__res_xhigh_po_0p35 l=24.92
X58 out.t1 x2.in.t5 gnd.t4 gnd.t3 sky130_fd_pr__nfet_01v8 ad=0.435 pd=3.58 as=0.435 ps=3.58 w=1.5 l=0.15
X59 x3.XM13.S x3.XM9.S x4.Set gnd.t43 sky130_fd_pr__nfet_01v8 ad=0.29 pd=2.58 as=0.29 ps=2.58 w=1 l=0.75
X60 x5.Phi_2.t2 x4.Rst.t3 Vdd.t45 Vdd.t44 sky130_fd_pr__pfet_01v8 ad=0.435 pd=3.58 as=0.435 ps=3.58 w=1.5 l=0.15
X61 x1.XM11.S x1.XM9.G x1.XM11.D.t0 gnd.t32 sky130_fd_pr__nfet_01v8 ad=0.406 pd=3.38 as=0.406 ps=3.38 w=1.4 l=0.75
X62 x5.sky130_fd_pr__res_xhigh_po_0p35_CBQ445_0.R1_1 x5.sky130_fd_pr__res_xhigh_po_0p35_CBQ445_0.R2_2 gnd.t16 sky130_fd_pr__res_xhigh_po_0p35 l=24.92
X63 x5.Vplus.t12 x5.sky130_fd_pr__cap_mim_m3_2_SLGBQV_0.C2 sky130_fd_pr__cap_mim_m3_2 l=15 w=26.15
X64 x4.sky130_fd_pr__nfet_01v8_3GJG22_1.D x5.Phi_2.t6 x5.Phi_1.t2 gnd.t75 sky130_fd_pr__nfet_01v8 ad=0.2175 pd=2.08 as=0.2175 ps=2.08 w=0.75 l=0.15
X65 Vdd.t23 x2.in.t6 x4.Rst.t2 Vdd.t22 sky130_fd_pr__pfet_01v8 ad=0.58 pd=4.58 as=0.58 ps=4.58 w=2 l=0.75
X66 x2.XM7.S x2.XM5.S gnd.t55 gnd.t54 sky130_fd_pr__nfet_01v8 ad=0.29 pd=2.58 as=0.29 ps=2.58 w=1 l=0.75
X67 x5.XM7.S Bit1.t1 x5.XC14.C2.t0 gnd.t17 sky130_fd_pr__nfet_01v8 ad=3.045 pd=21.58 as=3.045 ps=21.58 w=10.5 l=0.15
X68 x4.XM6.S x4.Rst.t4 gnd.t2 gnd.t1 sky130_fd_pr__nfet_01v8 ad=0.2175 pd=2.08 as=0.2175 ps=2.08 w=0.75 l=0.15
X69 x5.sky130_fd_pr__res_xhigh_po_0p35_CBQ445_2.R2_2.t1 x5.XM20.G Vdd.t19 Vdd.t18 sky130_fd_pr__pfet_01v8 ad=5.568 pd=38.98 as=5.568 ps=38.98 w=19.2 l=0.15
X70 Vdd.t11 x1.XM3.D.t1 x1.XM3.D.t2 Vdd.t10 sky130_fd_pr__pfet_01v8 ad=2.175 pd=15.58 as=2.175 ps=15.58 w=7.5 l=0.75
X71 x2.XM5.S x2.XM3.S Vdd.t53 Vdd.t52 sky130_fd_pr__pfet_01v8 ad=0.58 pd=4.58 as=0.58 ps=4.58 w=2 l=0.75
X72 x5.sky130_fd_pr__res_xhigh_po_0p35_CBQ445_3.R1_0 x5.Vminus.t1 gnd.t22 sky130_fd_pr__res_xhigh_po_0p35 l=24.92
X73 x5.XC3.C2.t0 Bit2.t1 gnd.t77 gnd.t76 sky130_fd_pr__nfet_01v8 ad=3.045 pd=21.58 as=3.045 ps=21.58 w=10.5 l=0.15
X74 x2.XM9.S x2.XM7.S Vdd.t41 Vdd.t40 sky130_fd_pr__pfet_01v8 ad=0.58 pd=4.58 as=0.58 ps=4.58 w=2 l=0.75
X75 x5.XM15.S Bit0.t0 x5.XC13.C2.t0 gnd.t18 sky130_fd_pr__nfet_01v8 ad=3.045 pd=21.58 as=3.045 ps=21.58 w=10.5 l=0.15
X76 x5.Vminus.t10 x5.XC14.C2 sky130_fd_pr__cap_mim_m3_2 l=15 w=6.4
X77 x5.Vminus.t11 x5.sky130_fd_pr__cap_mim_m3_2_SLGBQV_8.C2.t1 sky130_fd_pr__cap_mim_m3_2 l=15 w=26.15
X78 x1.sky130_fd_pr__res_xhigh_po_0p35_T68YWU_0.R1_0 x5.Vplus.t1 gnd.t11 sky130_fd_pr__res_xhigh_po_0p35 l=28.81
X79 x5.sky130_fd_pr__res_xhigh_po_0p35_CBQ445_0.R1_1 x5.sky130_fd_pr__res_xhigh_po_0p35_CBQ445_0.R2_0 gnd.t80 sky130_fd_pr__res_xhigh_po_0p35 l=24.92
X80 gnd.t70 rst_rc.t2 x5.Vminus.t0 gnd.t68 sky130_fd_pr__nfet_01v8 ad=3.045 pd=21.58 as=3.045 ps=21.58 w=10.5 l=0.15
X81 x2.XM1.S x2.in.t7 Vdd.t31 Vdd.t30 sky130_fd_pr__pfet_01v8 ad=0.58 pd=4.58 as=0.58 ps=4.58 w=2 l=0.15
X82 x3.XM7.S x3.XM5.S Vdd.t15 Vdd.t14 sky130_fd_pr__pfet_01v8 ad=0.58 pd=4.58 as=0.58 ps=4.58 w=2 l=0.75
X83 Vdd.t39 x4.Set x5.Phi_1.t0 Vdd.t38 sky130_fd_pr__pfet_01v8 ad=0.435 pd=3.58 as=0.435 ps=3.58 w=1.5 l=0.15
X84 x1.sky130_fd_pr__res_xhigh_po_0p35_T68YWU_0.R1_0 out.t0 gnd.t11 sky130_fd_pr__res_xhigh_po_0p35 l=28.81
X85 x2.XM13.S x2.XM9.S x4.Rst.t0 gnd.t13 sky130_fd_pr__nfet_01v8 ad=0.29 pd=2.58 as=0.29 ps=2.58 w=1 l=0.75
X86 x5.Vplus.t13 x5.sky130_fd_pr__cap_mim_m3_2_SLGBQV_5.C2.t1 sky130_fd_pr__cap_mim_m3_2 l=15 w=26.15
X87 x5.sky130_fd_pr__res_xhigh_po_0p35_CBQ445_1.R1_2 x5.sky130_fd_pr__res_xhigh_po_0p35_CBQ445_1.R2_1 gnd.t42 sky130_fd_pr__res_xhigh_po_0p35 l=24.92
X88 x5.Vplus.t0 x5.sky130_fd_pr__res_xhigh_po_0p35_CBQ445_2.R2_0 gnd.t46 sky130_fd_pr__res_xhigh_po_0p35 l=24.92
X89 x1.XM9.G x1.XM11.D.t3 Vdd.t43 Vdd.t42 sky130_fd_pr__pfet_01v8 ad=2.175 pd=15.58 as=2.175 ps=15.58 w=7.5 l=0.75
X90 x3.XM3.S x3.XM1.S gnd.t27 gnd.t26 sky130_fd_pr__nfet_01v8 ad=0.29 pd=2.58 as=0.29 ps=2.58 w=1 l=0.75
X91 x5.Vminus.t12 x5.sky130_fd_pr__cap_mim_m3_2_SLGBQV_8.C2.t2 sky130_fd_pr__cap_mim_m3_2 l=15 w=26.15
X92 x5.XM12.S Bit4.t1 x5.XC5.C2.t0 gnd.t57 sky130_fd_pr__nfet_01v8 ad=3.045 pd=21.58 as=3.045 ps=21.58 w=10.5 l=0.15
X93 gnd.t31 x1.XM9.G x1.XM3.S gnd.t30 sky130_fd_pr__nfet_01v8 ad=2.03 pd=14.58 as=2.03 ps=14.58 w=7 l=0.75
X94 x1.XM4.S x1.XM3.D.t3 Vdd.t25 Vdd.t24 sky130_fd_pr__pfet_01v8 ad=2.175 pd=15.58 as=2.175 ps=15.58 w=7.5 l=0.75
X95 x4.Set x3.XM9.S Vdd.t27 Vdd.t26 sky130_fd_pr__pfet_01v8 ad=0.58 pd=4.58 as=0.58 ps=4.58 w=2 l=0.75
X96 x5.XC1.C2.t0 Bit0.t1 gnd.t51 gnd.t50 sky130_fd_pr__nfet_01v8 ad=3.045 pd=21.58 as=3.045 ps=21.58 w=10.5 l=0.15
X97 x5.sky130_fd_pr__cap_mim_m3_2_SLGBQV_5.C2.t0 Bit5.t1 gnd.t82 gnd.t81 sky130_fd_pr__nfet_01v8 ad=3.045 pd=21.58 as=3.045 ps=21.58 w=10.5 l=0.15
X98 x5.Vplus.t14 x5.XC3.C2 sky130_fd_pr__cap_mim_m3_2 l=15 w=13
X99 x5.Vminus.t13 x5.sky130_fd_pr__cap_mim_m3_2_SLGBQV_8.C2.t1 sky130_fd_pr__cap_mim_m3_2 l=15 w=26.15
X100 x5.sky130_fd_pr__res_xhigh_po_0p35_CBQ445_1.R1_0 x5.sky130_fd_pr__res_xhigh_po_0p35_CBQ445_1.R2_1 gnd.t21 sky130_fd_pr__res_xhigh_po_0p35 l=24.92
X101 x1.XM11.S gnd.t41 gnd.t40 sky130_fd_pr__res_xhigh_po_0p35 l=17.3
X102 Vdd.t9 x5.Phi_1.t6 x5.sky130_fd_pr__res_xhigh_po_0p35_CBQ445_2.R2_2.t2 Vdd.t8 sky130_fd_pr__pfet_01v8 ad=5.568 pd=38.98 as=5.568 ps=38.98 w=19.2 l=0.15
X103 x5.XM20.G rst_rc.t3 gnd.t37 gnd.t36 sky130_fd_pr__nfet_01v8 ad=0.29 pd=2.58 as=0.29 ps=2.58 w=1 l=0.15
X104 gnd.t15 out.t6 x3.XM13.S gnd.t14 sky130_fd_pr__nfet_01v8 ad=0.29 pd=2.58 as=0.29 ps=2.58 w=1 l=0.75
X105 gnd.t65 x4.Set x4.sky130_fd_pr__nfet_01v8_3GJG22_1.D gnd.t64 sky130_fd_pr__nfet_01v8 ad=0.2175 pd=2.08 as=0.2175 ps=2.08 w=0.75 l=0.15
R0 Bit4 Bit4.t0 1898.45
R1 Bit4 Bit4.t1 1898.45
R2 Bit4.n0 Bit4 19.2959
R3 Bit4.n0 Bit4 0.123
R4 Bit4.n0 Bit4 0.120215
R5 Bit4 Bit4.n0 0.0534762
R6 gnd.n323 gnd.n322 2.64119e+06
R7 gnd.n324 gnd.n323 1.01824e+06
R8 gnd.n449 gnd.n424 814936
R9 gnd.n515 gnd.n441 32546.6
R10 gnd.n523 gnd.n436 20997.9
R11 gnd.n523 gnd.n437 20997.9
R12 gnd.n438 gnd.n436 20997.9
R13 gnd.n438 gnd.n437 20997.9
R14 gnd.n309 gnd.n218 19224.9
R15 gnd.n309 gnd.n219 19224.9
R16 gnd.n310 gnd.n218 19224.9
R17 gnd.n310 gnd.n219 19224.9
R18 gnd.n256 gnd.n240 19224.9
R19 gnd.n256 gnd.n244 19224.9
R20 gnd.n257 gnd.n240 19224.9
R21 gnd.n257 gnd.n244 19224.9
R22 gnd.n285 gnd.n232 19224.9
R23 gnd.n281 gnd.n232 19224.9
R24 gnd.n285 gnd.n282 19224.9
R25 gnd.n282 gnd.n281 19224.9
R26 gnd.n321 gnd.n205 19224.9
R27 gnd.n248 gnd.n205 19224.9
R28 gnd.n321 gnd.n206 19224.9
R29 gnd.n248 gnd.n206 19224.9
R30 gnd.n449 gnd.n441 17251.2
R31 gnd.n499 gnd.n487 13847.9
R32 gnd.n506 gnd.n487 13847.9
R33 gnd.n506 gnd.n486 13847.9
R34 gnd.n499 gnd.n486 13847.9
R35 gnd.n468 gnd.n450 10649.3
R36 gnd.n568 gnd.n44 8794.21
R37 gnd.n323 gnd.n203 8241.88
R38 gnd.n450 gnd.n449 8209.22
R39 gnd.n559 gnd.n52 7630.85
R40 gnd.n559 gnd.n53 7630.85
R41 gnd.n561 gnd.n53 7630.85
R42 gnd.n561 gnd.n52 7630.85
R43 gnd.n385 gnd.n155 7630.85
R44 gnd.n382 gnd.n155 7630.85
R45 gnd.n385 gnd.n157 7630.85
R46 gnd.n382 gnd.n157 7630.85
R47 gnd.n393 gnd.n145 7630.85
R48 gnd.n393 gnd.n146 7630.85
R49 gnd.n395 gnd.n145 7630.85
R50 gnd.n395 gnd.n146 7630.85
R51 gnd.n161 gnd.n160 7630.85
R52 gnd.n376 gnd.n161 7630.85
R53 gnd.n377 gnd.n160 7630.85
R54 gnd.n377 gnd.n376 7630.85
R55 gnd.n335 gnd.n191 7630.85
R56 gnd.n335 gnd.n194 7630.85
R57 gnd.n337 gnd.n191 7630.85
R58 gnd.n337 gnd.n194 7630.85
R59 gnd.n306 gnd.n297 7630.85
R60 gnd.n298 gnd.n297 7630.85
R61 gnd.n306 gnd.n305 7630.85
R62 gnd.n305 gnd.n298 7630.85
R63 gnd.n289 gnd.n221 7630.85
R64 gnd.n224 gnd.n221 7630.85
R65 gnd.n289 gnd.n225 7630.85
R66 gnd.n225 gnd.n224 7630.85
R67 gnd.n234 gnd.n214 7630.85
R68 gnd.n312 gnd.n214 7630.85
R69 gnd.n234 gnd.n215 7630.85
R70 gnd.n312 gnd.n215 7630.85
R71 gnd.n352 gnd.n151 7630.85
R72 gnd.n388 gnd.n151 7630.85
R73 gnd.n388 gnd.n152 7630.85
R74 gnd.n352 gnd.n152 7630.85
R75 gnd.n345 gnd.n183 7630.85
R76 gnd.n345 gnd.n184 7630.85
R77 gnd.n347 gnd.n183 7630.85
R78 gnd.n347 gnd.n184 7630.85
R79 gnd.n326 gnd.n196 7630.85
R80 gnd.n331 gnd.n196 7630.85
R81 gnd.n326 gnd.n197 7630.85
R82 gnd.n331 gnd.n197 7630.85
R83 gnd.n228 gnd.n227 7630.85
R84 gnd.n227 gnd.n212 7630.85
R85 gnd.n287 gnd.n228 7630.85
R86 gnd.n287 gnd.n212 7630.85
R87 gnd.n245 gnd.n210 7630.85
R88 gnd.n315 gnd.n210 7630.85
R89 gnd.n245 gnd.n211 7630.85
R90 gnd.n315 gnd.n211 7630.85
R91 gnd.n549 gnd.n399 7630.85
R92 gnd.n400 gnd.n399 7630.85
R93 gnd.n549 gnd.n548 7630.85
R94 gnd.n548 gnd.n400 7630.85
R95 gnd.n545 gnd.n47 7630.85
R96 gnd.n545 gnd.n48 7630.85
R97 gnd.n566 gnd.n48 7630.85
R98 gnd.n566 gnd.n47 7630.85
R99 gnd.n538 gnd.n404 7630.85
R100 gnd.n538 gnd.n405 7630.85
R101 gnd.n541 gnd.n405 7630.85
R102 gnd.n541 gnd.n404 7630.85
R103 gnd.n500 gnd.n441 7592.82
R104 gnd.n535 gnd.n413 6130.18
R105 gnd.n421 gnd.n413 6130.18
R106 gnd.n535 gnd.n414 6130.18
R107 gnd.n421 gnd.n414 6130.18
R108 gnd.n530 gnd.n419 4247.09
R109 gnd.n531 gnd.n419 4247.09
R110 gnd.n526 gnd.n432 4247.09
R111 gnd.n525 gnd.n432 4247.09
R112 gnd.n203 gnd.n44 3850.49
R113 gnd.n429 gnd.n426 2983.97
R114 gnd.n429 gnd.n420 2983.97
R115 gnd.n513 gnd.n442 2885.47
R116 gnd.n443 gnd.n442 2885.47
R117 gnd.n513 gnd.n511 2885.47
R118 gnd.n511 gnd.n443 2885.47
R119 gnd.n521 gnd.n439 2479.88
R120 gnd.n517 gnd.n439 2479.88
R121 gnd.n521 gnd.n518 2479.88
R122 gnd.n518 gnd.n517 2479.88
R123 gnd.n85 gnd.n82 2474.09
R124 gnd.n84 gnd.n82 2474.09
R125 gnd.n596 gnd.n5 2474.09
R126 gnd.n597 gnd.n5 2474.09
R127 gnd.n461 gnd.n451 2416.15
R128 gnd.n466 gnd.n451 2416.15
R129 gnd.n466 gnd.n452 2416.15
R130 gnd.n461 gnd.n452 2416.15
R131 gnd.n255 gnd.n254 2126.44
R132 gnd.n255 gnd.n236 2126.44
R133 gnd.n254 gnd.n251 2126.44
R134 gnd.n251 gnd.n236 2126.44
R135 gnd.n117 gnd.n109 2126.44
R136 gnd.n118 gnd.n109 2126.44
R137 gnd.n570 gnd.n41 2126.44
R138 gnd.n571 gnd.n570 2126.44
R139 gnd.n368 gnd.n168 1981.59
R140 gnd.n369 gnd.n168 1981.59
R141 gnd.n373 gnd.n163 1981.59
R142 gnd.n373 gnd.n164 1981.59
R143 gnd.n343 gnd.n185 1981.59
R144 gnd.n343 gnd.n186 1981.59
R145 gnd.n358 gnd.n356 1981.59
R146 gnd.n356 gnd.n354 1981.59
R147 gnd.n472 gnd.n447 1981.59
R148 gnd.n472 gnd.n471 1981.59
R149 gnd.n471 gnd.n448 1981.59
R150 gnd.n448 gnd.n447 1981.59
R151 gnd.n459 gnd.n450 1731.08
R152 gnd.n370 gnd.n165 1363.2
R153 gnd.n530 gnd.n426 1263.12
R154 gnd.n526 gnd.n426 1263.12
R155 gnd.n531 gnd.n420 1263.12
R156 gnd.n525 gnd.n420 1263.12
R157 gnd.n85 gnd.n80 1263.12
R158 gnd.n91 gnd.n80 1263.12
R159 gnd.n91 gnd.n72 1263.12
R160 gnd.n95 gnd.n72 1263.12
R161 gnd.n95 gnd.n67 1263.12
R162 gnd.n126 gnd.n67 1263.12
R163 gnd.n126 gnd.n68 1263.12
R164 gnd.n122 gnd.n68 1263.12
R165 gnd.n122 gnd.n101 1263.12
R166 gnd.n113 gnd.n101 1263.12
R167 gnd.n113 gnd.n112 1263.12
R168 gnd.n84 gnd.n78 1263.12
R169 gnd.n92 gnd.n78 1263.12
R170 gnd.n92 gnd.n74 1263.12
R171 gnd.n94 gnd.n74 1263.12
R172 gnd.n94 gnd.n63 1263.12
R173 gnd.n127 gnd.n63 1263.12
R174 gnd.n127 gnd.n64 1263.12
R175 gnd.n121 gnd.n64 1263.12
R176 gnd.n121 gnd.n103 1263.12
R177 gnd gnd.n103 1263.12
R178 gnd.n108 gnd 1263.12
R179 gnd.n596 gnd.n9 1263.12
R180 gnd.n592 gnd.n9 1263.12
R181 gnd.n592 gnd.n13 1263.12
R182 gnd.n588 gnd.n13 1263.12
R183 gnd.n588 gnd.n21 1263.12
R184 gnd.n584 gnd.n21 1263.12
R185 gnd.n584 gnd.n25 1263.12
R186 gnd.n580 gnd.n25 1263.12
R187 gnd.n580 gnd.n34 1263.12
R188 gnd.n576 gnd.n34 1263.12
R189 gnd.n576 gnd.n38 1263.12
R190 gnd.n597 gnd.n6 1263.12
R191 gnd.n591 gnd.n6 1263.12
R192 gnd.n591 gnd.n15 1263.12
R193 gnd.n589 gnd.n15 1263.12
R194 gnd.n589 gnd.n19 1263.12
R195 gnd.n583 gnd.n19 1263.12
R196 gnd.n583 gnd.n27 1263.12
R197 gnd.n581 gnd.n27 1263.12
R198 gnd.n581 gnd.n32 1263.12
R199 gnd gnd.n32 1263.12
R200 gnd.n39 gnd 1263.12
R201 gnd.n574 gnd.n38 1210.97
R202 gnd.n574 gnd.n39 1210.97
R203 gnd.n35 gnd.n34 1210.97
R204 gnd.n35 gnd.n32 1210.97
R205 gnd.n29 gnd.n25 1210.97
R206 gnd.n29 gnd.n27 1210.97
R207 gnd.n22 gnd.n21 1210.97
R208 gnd.n22 gnd.n19 1210.97
R209 gnd.n16 gnd.n13 1210.97
R210 gnd.n16 gnd.n15 1210.97
R211 gnd.n112 gnd.n111 1210.97
R212 gnd.n111 gnd.n108 1210.97
R213 gnd.n104 gnd.n101 1210.97
R214 gnd.n104 gnd.n103 1210.97
R215 gnd.n98 gnd.n68 1210.97
R216 gnd.n98 gnd.n64 1210.97
R217 gnd.n69 gnd.n67 1210.97
R218 gnd.n69 gnd.n63 1210.97
R219 gnd.n75 gnd.n72 1210.97
R220 gnd.n75 gnd.n74 1210.97
R221 gnd.n87 gnd.n80 1210.97
R222 gnd.n87 gnd.n78 1210.97
R223 gnd.n10 gnd.n9 1210.97
R224 gnd.n10 gnd.n6 1210.97
R225 gnd.n504 gnd.n501 1096.08
R226 gnd.n173 gnd.n172 1066.12
R227 gnd.n172 gnd.n169 1066.12
R228 gnd.n361 gnd.n176 1066.12
R229 gnd.n361 gnd.n177 1066.12
R230 gnd.n349 gnd.n181 1010.2
R231 gnd.n203 gnd.n7 961.04
R232 gnd.n368 gnd.n173 915.471
R233 gnd.n173 gnd.n163 915.471
R234 gnd.n369 gnd.n169 915.471
R235 gnd.n169 gnd.n164 915.471
R236 gnd.n185 gnd.n176 915.471
R237 gnd.n358 gnd.n176 915.471
R238 gnd.n186 gnd.n177 915.471
R239 gnd.n354 gnd.n177 915.471
R240 gnd.n117 gnd.n112 915.471
R241 gnd.n118 gnd.n108 915.471
R242 gnd.n41 gnd.n38 915.471
R243 gnd.n571 gnd.n39 915.471
R244 gnd.t5 gnd.n83 687.106
R245 gnd.t5 gnd.n79 687.106
R246 gnd.t13 gnd.n79 687.106
R247 gnd.t13 gnd.n73 687.106
R248 gnd.t66 gnd.n73 687.106
R249 gnd.t66 gnd.n65 687.106
R250 gnd.t54 gnd.n65 687.106
R251 gnd.t54 gnd.n66 687.106
R252 gnd.t73 gnd.n66 687.106
R253 gnd.t73 gnd.n102 687.106
R254 gnd.t71 gnd.n102 687.106
R255 gnd.t71 gnd.n110 687.106
R256 gnd.n501 gnd.n500 667.702
R257 gnd gnd.n40 594.845
R258 gnd.n408 gnd.n407 564.33
R259 gnd.n340 gnd.n339 551.201
R260 gnd.n339 gnd.n338 547.529
R261 gnd.n408 gnd.n406 513.83
R262 gnd.t19 gnd.n110 497.995
R263 gnd.t19 gnd.n45 497.995
R264 gnd.n384 gnd.n383 495.812
R265 gnd gnd.n384 495.812
R266 gnd.n302 gnd.n301 495.812
R267 gnd.n392 gnd.n143 495.812
R268 gnd.n392 gnd.n391 492.048
R269 gnd.n338 gnd.n190 490.918
R270 gnd.n199 gnd.n198 490.918
R271 gnd.n390 gnd.n149 489.788
R272 gnd.n563 gnd.n562 489.788
R273 gnd.n562 gnd.n51 489.788
R274 gnd.n278 gnd.n277 471.587
R275 gnd gnd.n181 466.973
R276 gnd.n568 gnd.n567 465.348
R277 gnd.n493 gnd.n492 451.921
R278 gnd.n179 gnd.n149 451.228
R279 gnd.n378 gnd.n159 443.303
R280 gnd.n539 gnd 443.116
R281 gnd.n339 gnd.n159 443.11
R282 gnd.n564 gnd.n563 439.307
R283 gnd.n540 gnd.n539 437.019
R284 gnd.n302 gnd.n296 436.329
R285 gnd.n407 gnd.n398 436.329
R286 gnd.n200 gnd.n199 436.329
R287 gnd.n565 gnd.n564 436.329
R288 gnd.n277 gnd.n233 411.908
R289 gnd.n295 gnd.n217 365.168
R290 gnd gnd.n235 322.204
R291 gnd.n292 gnd.n221 308.978
R292 gnd.n275 gnd.n217 299.521
R293 gnd.n500 gnd.n499 295.63
R294 gnd gnd.n118 292.5
R295 gnd.n118 gnd.t19 292.5
R296 gnd.n117 gnd.n116 292.5
R297 gnd.t19 gnd.n117 292.5
R298 gnd.n499 gnd.n498 292.5
R299 gnd.n453 gnd.n447 292.5
R300 gnd.t52 gnd.n447 292.5
R301 gnd gnd.n506 292.5
R302 gnd.n506 gnd.t40 292.5
R303 gnd gnd.n538 292.5
R304 gnd.n538 gnd.n537 292.5
R305 gnd.n409 gnd.n400 292.5
R306 gnd.n544 gnd.n400 292.5
R307 gnd.n541 gnd.n540 292.5
R308 gnd.n542 gnd.n541 292.5
R309 gnd gnd.n549 292.5
R310 gnd.n549 gnd.n46 292.5
R311 gnd.n211 gnd 292.5
R312 gnd.t9 gnd.n211 292.5
R313 gnd.n230 gnd.n210 292.5
R314 gnd.t9 gnd.n210 292.5
R315 gnd.n287 gnd 292.5
R316 gnd.t68 gnd.n287 292.5
R317 gnd.n274 gnd.n227 292.5
R318 gnd.t68 gnd.n227 292.5
R319 gnd.n331 gnd.n330 292.5
R320 gnd.n332 gnd.n331 292.5
R321 gnd gnd.n326 292.5
R322 gnd.n326 gnd.n325 292.5
R323 gnd.n184 gnd.n180 292.5
R324 gnd.n184 gnd.n178 292.5
R325 gnd.n183 gnd 292.5
R326 gnd.n334 gnd.n183 292.5
R327 gnd.n352 gnd 292.5
R328 gnd.n353 gnd.n352 292.5
R329 gnd.n251 gnd 292.5
R330 gnd.t36 gnd.n251 292.5
R331 gnd.n255 gnd.n238 292.5
R332 gnd.t36 gnd.n255 292.5
R333 gnd gnd.n215 292.5
R334 gnd.t68 gnd.n215 292.5
R335 gnd.n242 gnd.n214 292.5
R336 gnd.t68 gnd.n214 292.5
R337 gnd gnd.n225 292.5
R338 gnd.n225 gnd.t38 292.5
R339 gnd.n221 gnd.t38 292.5
R340 gnd.n301 gnd.n298 292.5
R341 gnd.n298 gnd.n195 292.5
R342 gnd gnd.n306 292.5
R343 gnd.n306 gnd.n201 292.5
R344 gnd.n194 gnd.n192 292.5
R345 gnd.n194 gnd.n193 292.5
R346 gnd gnd.n191 292.5
R347 gnd.n333 gnd.n191 292.5
R348 gnd gnd.n161 292.5
R349 gnd.n359 gnd.n161 292.5
R350 gnd.n354 gnd 292.5
R351 gnd.t75 gnd.n354 292.5
R352 gnd gnd.n186 292.5
R353 gnd.n186 gnd.t64 292.5
R354 gnd.n187 gnd.n185 292.5
R355 gnd.n185 gnd.t64 292.5
R356 gnd.n358 gnd.n357 292.5
R357 gnd.t75 gnd.n358 292.5
R358 gnd gnd.n164 292.5
R359 gnd.t1 gnd.n164 292.5
R360 gnd gnd.n369 292.5
R361 gnd.n369 gnd.t8 292.5
R362 gnd.n368 gnd.n367 292.5
R363 gnd.t8 gnd.n368 292.5
R364 gnd.n365 gnd.n163 292.5
R365 gnd.t1 gnd.n163 292.5
R366 gnd.n389 gnd.n388 292.5
R367 gnd.n388 gnd.n387 292.5
R368 gnd.n146 gnd.n143 292.5
R369 gnd.n202 gnd.n146 292.5
R370 gnd gnd.n145 292.5
R371 gnd.n154 gnd.n145 292.5
R372 gnd.n378 gnd.n377 292.5
R373 gnd.n377 gnd.n153 292.5
R374 gnd.n383 gnd.n382 292.5
R375 gnd.n382 gnd.n147 292.5
R376 gnd.n385 gnd 292.5
R377 gnd.n386 gnd.n385 292.5
R378 gnd.n42 gnd.n41 292.5
R379 gnd.n41 gnd.t62 292.5
R380 gnd gnd.n571 292.5
R381 gnd.n571 gnd.t62 292.5
R382 gnd.n566 gnd 292.5
R383 gnd.n567 gnd.n566 292.5
R384 gnd.n545 gnd.n50 292.5
R385 gnd.n546 gnd.n545 292.5
R386 gnd.n52 gnd 292.5
R387 gnd.n543 gnd.n52 292.5
R388 gnd.n58 gnd.n53 292.5
R389 gnd.n470 gnd.n53 292.5
R390 gnd.n464 gnd.n451 292.5
R391 gnd.n451 gnd.t3 292.5
R392 gnd.n471 gnd 292.5
R393 gnd.n471 gnd.t52 292.5
R394 gnd gnd.n452 292.5
R395 gnd.n452 gnd.t3 292.5
R396 gnd.n303 gnd.n195 287.224
R397 gnd.n311 gnd 284.077
R398 gnd.n484 gnd.n59 268.947
R399 gnd.t17 gnd.n334 267.373
R400 gnd.n162 gnd.n153 261.858
R401 gnd.n394 gnd.n147 257.966
R402 gnd.t84 gnd.n154 250.421
R403 gnd.n325 gnd.n324 241.15
R404 gnd.n346 gnd.n344 227.917
R405 gnd.n379 gnd.n158 219.31
R406 gnd.n503 gnd.n502 217.344
R407 gnd.n528 gnd.n430 193.882
R408 gnd.n430 gnd.n418 193.882
R409 gnd.n349 gnd.n348 187.218
R410 gnd.n320 gnd 186
R411 gnd.n320 gnd.n207 182.46
R412 gnd.n547 gnd.n546 173.017
R413 gnd.n498 gnd.n493 170.585
R414 gnd.n83 gnd.n44 167.049
R415 gnd.n568 gnd.n45 167.049
R416 gnd.t57 gnd.n46 166.964
R417 gnd.n505 gnd.n504 162.464
R418 gnd.n86 gnd.n81 160.754
R419 gnd.n595 gnd.n3 160.754
R420 gnd.n489 gnd.n488 157.725
R421 gnd.n275 gnd 157.44
R422 gnd.n542 gnd.n403 154.661
R423 gnd.n239 gnd.n222 153.988
R424 gnd.n464 gnd.n463 153.601
R425 gnd.n247 gnd.n246 150.474
R426 gnd.n383 gnd.n2 148.707
R427 gnd gnd.n239 147.625
R428 gnd.n301 gnd.n300 146.447
R429 gnd.n397 gnd.n143 146.447
R430 gnd.n356 gnd.n174 146.256
R431 gnd.n259 gnd.n236 146.254
R432 gnd.n88 gnd.n87 146.25
R433 gnd.n87 gnd.n79 146.25
R434 gnd.n76 gnd.n75 146.25
R435 gnd.n75 gnd.n73 146.25
R436 gnd.n70 gnd.n69 146.25
R437 gnd.n69 gnd.n65 146.25
R438 gnd.n99 gnd.n98 146.25
R439 gnd.n98 gnd.n66 146.25
R440 gnd.n105 gnd.n104 146.25
R441 gnd.n104 gnd.n102 146.25
R442 gnd.n111 gnd.n106 146.25
R443 gnd.n111 gnd.n110 146.25
R444 gnd.n109 gnd.n107 146.25
R445 gnd.n109 gnd.n45 146.25
R446 gnd.n121 gnd 146.25
R447 gnd.t73 gnd.n121 146.25
R448 gnd gnd.n127 146.25
R449 gnd.n127 gnd.t54 146.25
R450 gnd.n94 gnd 146.25
R451 gnd.t66 gnd.n94 146.25
R452 gnd gnd.n92 146.25
R453 gnd.n92 gnd.t13 146.25
R454 gnd.n84 gnd 146.25
R455 gnd.t5 gnd.n84 146.25
R456 gnd.n82 gnd.n81 146.25
R457 gnd.n83 gnd.n82 146.25
R458 gnd.n86 gnd.n85 146.25
R459 gnd.n85 gnd.t5 146.25
R460 gnd.n91 gnd.n90 146.25
R461 gnd.t13 gnd.n91 146.25
R462 gnd.n96 gnd.n95 146.25
R463 gnd.n95 gnd.t66 146.25
R464 gnd.n126 gnd.n125 146.25
R465 gnd.t54 gnd.n126 146.25
R466 gnd.n123 gnd.n122 146.25
R467 gnd.n122 gnd.t73 146.25
R468 gnd.n114 gnd.n113 146.25
R469 gnd.n113 gnd.t71 146.25
R470 gnd.n484 gnd.n437 146.25
R471 gnd.n504 gnd.n437 146.25
R472 gnd gnd.n414 146.25
R473 gnd.n414 gnd.t30 146.25
R474 gnd.n445 gnd.n413 146.25
R475 gnd.n413 gnd.t30 146.25
R476 gnd.n525 gnd 146.25
R477 gnd.t56 gnd.n525 146.25
R478 gnd gnd.n531 146.25
R479 gnd.n531 gnd.t0 146.25
R480 gnd.n530 gnd.n529 146.25
R481 gnd.t0 gnd.n530 146.25
R482 gnd.n527 gnd.n526 146.25
R483 gnd.n526 gnd.t56 146.25
R484 gnd.n517 gnd.n440 146.25
R485 gnd.n517 gnd.n516 146.25
R486 gnd gnd.n518 146.25
R487 gnd.n518 gnd.t33 146.25
R488 gnd.n521 gnd.n520 146.25
R489 gnd.n522 gnd.n521 146.25
R490 gnd.n488 gnd.n439 146.25
R491 gnd.n439 gnd.t33 146.25
R492 gnd.n511 gnd 146.25
R493 gnd.n511 gnd.t32 146.25
R494 gnd.n490 gnd.n442 146.25
R495 gnd.n442 gnd.t32 146.25
R496 gnd.n250 gnd.n236 146.25
R497 gnd.n254 gnd.n252 146.25
R498 gnd.n254 gnd.n253 146.25
R499 gnd.n362 gnd.n361 146.25
R500 gnd.n361 gnd.n360 146.25
R501 gnd.n356 gnd.n355 146.25
R502 gnd.n343 gnd.n342 146.25
R503 gnd.n344 gnd.n343 146.25
R504 gnd.n172 gnd.n166 146.25
R505 gnd.n172 gnd.n171 146.25
R506 gnd.n373 gnd.n372 146.25
R507 gnd.n374 gnd.n373 146.25
R508 gnd.n364 gnd.n168 146.25
R509 gnd.n170 gnd.n168 146.25
R510 gnd.n17 gnd.n16 146.25
R511 gnd.n16 gnd.n14 146.25
R512 gnd.n23 gnd.n22 146.25
R513 gnd.n22 gnd.n20 146.25
R514 gnd.n30 gnd.n29 146.25
R515 gnd.n29 gnd.n26 146.25
R516 gnd.n36 gnd.n35 146.25
R517 gnd.n35 gnd.n33 146.25
R518 gnd.n574 gnd.n573 146.25
R519 gnd.n575 gnd.n574 146.25
R520 gnd.n11 gnd.n10 146.25
R521 gnd.n10 gnd.n8 146.25
R522 gnd.n5 gnd.n3 146.25
R523 gnd.n7 gnd.n5 146.25
R524 gnd.n596 gnd.n595 146.25
R525 gnd.t14 gnd.n596 146.25
R526 gnd.n593 gnd.n592 146.25
R527 gnd.n592 gnd.t43 146.25
R528 gnd.n588 gnd.n587 146.25
R529 gnd.t44 gnd.n588 146.25
R530 gnd.n585 gnd.n584 146.25
R531 gnd.n584 gnd.t23 146.25
R532 gnd.n580 gnd.n579 146.25
R533 gnd.t78 gnd.n580 146.25
R534 gnd.n577 gnd.n576 146.25
R535 gnd.n576 gnd.t26 146.25
R536 gnd.n570 gnd.n43 146.25
R537 gnd.n570 gnd.n569 146.25
R538 gnd gnd.n581 146.25
R539 gnd.n581 gnd.t78 146.25
R540 gnd.n583 gnd 146.25
R541 gnd.t23 gnd.n583 146.25
R542 gnd gnd.n589 146.25
R543 gnd.n589 gnd.t44 146.25
R544 gnd.n591 gnd 146.25
R545 gnd.t43 gnd.n591 146.25
R546 gnd gnd.n597 146.25
R547 gnd.n597 gnd.t14 146.25
R548 gnd gnd.n436 146.25
R549 gnd.n436 gnd.n403 146.25
R550 gnd.n454 gnd.n448 146.25
R551 gnd.n469 gnd.n448 146.25
R552 gnd.n473 gnd.n472 146.25
R553 gnd.n472 gnd.n412 146.25
R554 gnd.n116 gnd.n107 138.166
R555 gnd.n43 gnd.n42 138.166
R556 gnd.n296 gnd.n295 120.537
R557 gnd.n278 gnd.n200 117.648
R558 gnd gnd.t34 117.358
R559 gnd gnd.t53 115.701
R560 gnd gnd.t65 115.701
R561 gnd gnd.t2 115.701
R562 gnd.n550 gnd 98.9841
R563 gnd.n461 gnd.n460 98.0199
R564 gnd.n462 gnd.n457 97.5064
R565 gnd.n466 gnd.n465 97.5035
R566 gnd.n491 gnd.n443 97.5005
R567 gnd.n502 gnd.n443 97.5005
R568 gnd.n513 gnd.n512 97.5005
R569 gnd.n514 gnd.n513 97.5005
R570 gnd.n462 gnd.n461 97.5005
R571 gnd.n467 gnd.n466 97.5005
R572 gnd.n355 gnd.n170 93.1274
R573 gnd gnd.n81 87.5132
R574 gnd gnd.n107 85.0829
R575 gnd gnd.n206 83.5719
R576 gnd.t47 gnd.n206 83.5719
R577 gnd.n237 gnd.n205 83.5719
R578 gnd.t47 gnd.n205 83.5719
R579 gnd.n282 gnd 83.5719
R580 gnd.n282 gnd.t80 83.5719
R581 gnd.n276 gnd.n232 83.5719
R582 gnd.n232 gnd.t80 83.5719
R583 gnd gnd.n257 83.5719
R584 gnd.n257 gnd.t7 83.5719
R585 gnd.n256 gnd.n222 83.5719
R586 gnd.t7 gnd.n256 83.5719
R587 gnd gnd.n310 83.5719
R588 gnd.n310 gnd.t21 83.5719
R589 gnd.n309 gnd.n308 83.5719
R590 gnd.t21 gnd.n309 83.5719
R591 gnd.n529 gnd.n528 82.0711
R592 gnd.n528 gnd.n527 82.0711
R593 gnd.n89 gnd.n86 82.0711
R594 gnd.n90 gnd.n89 82.0711
R595 gnd.n90 gnd.n71 82.0711
R596 gnd.n96 gnd.n71 82.0711
R597 gnd.n97 gnd.n96 82.0711
R598 gnd.n125 gnd.n97 82.0711
R599 gnd.n125 gnd.n124 82.0711
R600 gnd.n124 gnd.n123 82.0711
R601 gnd.n123 gnd.n100 82.0711
R602 gnd.n114 gnd.n100 82.0711
R603 gnd.n115 gnd.n114 82.0711
R604 gnd.n595 gnd.n594 82.0711
R605 gnd.n594 gnd.n593 82.0711
R606 gnd.n593 gnd.n12 82.0711
R607 gnd.n587 gnd.n12 82.0711
R608 gnd.n587 gnd.n586 82.0711
R609 gnd.n586 gnd.n585 82.0711
R610 gnd.n585 gnd.n24 82.0711
R611 gnd.n579 gnd.n24 82.0711
R612 gnd.n579 gnd.n578 82.0711
R613 gnd.n578 gnd.n577 82.0711
R614 gnd.n577 gnd.n37 82.0711
R615 gnd gnd.t37 79.0672
R616 gnd gnd.t15 79.0672
R617 gnd gnd.t45 79.0672
R618 gnd gnd.t24 79.0672
R619 gnd gnd.t79 79.0672
R620 gnd gnd.t27 79.0672
R621 gnd gnd.t63 79.0672
R622 gnd gnd.t6 79.0672
R623 gnd gnd.t67 79.0672
R624 gnd gnd.t55 79.0672
R625 gnd gnd.t74 79.0672
R626 gnd gnd.t72 79.0672
R627 gnd gnd.t20 79.0672
R628 gnd.n573 gnd.n37 78.6829
R629 gnd.n573 gnd.n572 78.6829
R630 gnd.n578 gnd.n36 78.6829
R631 gnd.n36 gnd.n31 78.6829
R632 gnd.n30 gnd.n24 78.6829
R633 gnd.n582 gnd.n30 78.6829
R634 gnd.n586 gnd.n23 78.6829
R635 gnd.n23 gnd.n18 78.6829
R636 gnd.n17 gnd.n12 78.6829
R637 gnd.n590 gnd.n17 78.6829
R638 gnd.n115 gnd.n106 78.6829
R639 gnd.n119 gnd.n106 78.6829
R640 gnd.n105 gnd.n100 78.6829
R641 gnd.n120 gnd.n105 78.6829
R642 gnd.n124 gnd.n99 78.6829
R643 gnd.n99 gnd.n62 78.6829
R644 gnd.n97 gnd.n70 78.6829
R645 gnd.n70 gnd.n61 78.6829
R646 gnd.n76 gnd.n71 78.6829
R647 gnd.n93 gnd.n76 78.6829
R648 gnd.n89 gnd.n88 78.6829
R649 gnd.n88 gnd.n77 78.6829
R650 gnd.n594 gnd.n11 78.6829
R651 gnd.n11 gnd.n4 78.6829
R652 gnd.n598 gnd.n3 78.6829
R653 gnd.n43 gnd.n40 78.6829
R654 gnd.n397 gnd.n396 77.4214
R655 gnd.n380 gnd.n2 77.1541
R656 gnd.n300 gnd.n294 76.6685
R657 gnd.n490 gnd.n489 76.4137
R658 gnd.n446 gnd.n445 75.7673
R659 gnd.n492 gnd.n490 75.6711
R660 gnd.n445 gnd.n428 75.6711
R661 gnd.n527 gnd.n431 75.6711
R662 gnd.n488 gnd.n431 75.6711
R663 gnd.n529 gnd.n428 74.9642
R664 gnd gnd.n182 73.6975
R665 gnd.n366 gnd.n166 69.2711
R666 gnd.n371 gnd.n166 69.2711
R667 gnd.n362 gnd.n175 69.2711
R668 gnd.n363 gnd.n362 69.2711
R669 gnd.n365 gnd.n165 67.3123
R670 gnd.n456 gnd 65.025
R671 gnd.n279 gnd.n201 63.7189
R672 gnd.n223 gnd.n220 63.3988
R673 gnd.n293 gnd.n220 62.4142
R674 gnd.n519 gnd.n432 61.1357
R675 gnd.n544 gnd.n543 60.9272
R676 gnd.n342 gnd.n187 60.5308
R677 gnd.n367 gnd.n366 59.4829
R678 gnd.n366 gnd.n365 59.4829
R679 gnd.n187 gnd.n175 59.4829
R680 gnd.n357 gnd.n175 59.4829
R681 gnd.n116 gnd.n115 59.4829
R682 gnd.n42 gnd.n37 59.4829
R683 gnd gnd.t4 57.8505
R684 gnd.n233 gnd.n229 57.5013
R685 gnd.n567 gnd.n46 56.6311
R686 gnd.n546 gnd.n544 56.6311
R687 gnd.t11 gnd.n433 56.6229
R688 gnd.n316 gnd.n209 56.1944
R689 gnd.n333 gnd.n332 55.3865
R690 gnd.n311 gnd.n216 55.3557
R691 gnd.n317 gnd.n316 55.2247
R692 gnd.n387 gnd.n386 55.0005
R693 gnd.n367 gnd.n364 53.6351
R694 gnd.n357 gnd.n174 53.6298
R695 gnd.n454 gnd.n453 53.6241
R696 gnd.n465 gnd.n464 53.622
R697 gnd gnd.n381 53.0829
R698 gnd.n299 gnd 53.0829
R699 gnd.n453 gnd.n446 53.0829
R700 gnd gnd.n144 53.0829
R701 gnd.n389 gnd.n150 53.0829
R702 gnd.n330 gnd.n329 53.0829
R703 gnd.n56 gnd 53.0829
R704 gnd.n557 gnd.n58 53.0829
R705 gnd.t14 gnd.n7 53.0536
R706 gnd.t14 gnd.n8 53.0536
R707 gnd.t43 gnd.n8 53.0536
R708 gnd.t43 gnd.n14 53.0536
R709 gnd.t44 gnd.n14 53.0536
R710 gnd.t44 gnd.n20 53.0536
R711 gnd.t23 gnd.n20 53.0536
R712 gnd.t23 gnd.n26 53.0536
R713 gnd.t78 gnd.n26 53.0536
R714 gnd.t78 gnd.n33 53.0536
R715 gnd.t26 gnd.n33 53.0536
R716 gnd.t26 gnd.n575 53.0536
R717 gnd.n423 gnd.n422 52.7029
R718 gnd.t58 gnd.n402 50.5775
R719 gnd.n348 gnd.n182 49.3271
R720 gnd.n543 gnd.n542 49.2105
R721 gnd.n536 gnd.t30 47.4762
R722 gnd.n422 gnd.t30 47.4762
R723 gnd.t0 gnd.n425 47.4762
R724 gnd.t56 gnd.n425 47.4762
R725 gnd.t56 gnd.n433 47.4762
R726 gnd.n522 gnd.t33 47.4762
R727 gnd.n516 gnd.t33 47.4762
R728 gnd.n514 gnd.t32 47.4762
R729 gnd.n502 gnd.t32 47.4762
R730 gnd.n485 gnd.n484 46.8449
R731 gnd.n284 gnd.n213 46.5639
R732 gnd.n516 gnd.n515 45.2985
R733 gnd.n430 gnd.n429 45.0005
R734 gnd.n429 gnd.n425 45.0005
R735 gnd.n433 gnd.n432 45.0005
R736 gnd.n427 gnd.n419 45.0005
R737 gnd.n423 gnd.n419 45.0005
R738 gnd.n468 gnd.n467 42.9029
R739 gnd.n498 gnd.n497 42.7983
R740 gnd.n261 gnd.n260 42.4451
R741 gnd.n537 gnd.n412 41.814
R742 gnd.n515 gnd.n514 41.814
R743 gnd.n469 gnd.n468 41.5962
R744 gnd.n482 gnd.t41 41.0016
R745 gnd.n512 gnd.n435 39.8565
R746 gnd.n344 gnd.t64 38.7217
R747 gnd.t8 gnd.n170 38.7217
R748 gnd.t8 gnd.n171 38.7217
R749 gnd.n171 gnd.t1 38.7217
R750 gnd.n324 gnd.t18 38.4766
R751 gnd.n575 gnd.t62 38.4518
R752 gnd.n569 gnd.t62 38.4518
R753 gnd.t42 gnd.t80 38.2315
R754 gnd.t21 gnd.t61 38.2315
R755 gnd.n424 gnd.n423 37.4584
R756 gnd gnd.n57 37.0167
R757 gnd.n463 gnd.n456 36.85
R758 gnd.t40 gnd.n501 36.3124
R759 gnd.n519 gnd 35.7864
R760 gnd.n599 gnd.n598 35.2315
R761 gnd.n467 gnd.t3 34.4095
R762 gnd.t52 gnd.n469 34.4095
R763 gnd.n283 gnd.t16 33.8203
R764 gnd.n280 gnd.t60 33.8203
R765 gnd.n495 gnd.n494 33.2074
R766 gnd.n482 gnd 33.0976
R767 gnd.n533 gnd 32.7584
R768 gnd.t40 gnd.n503 32.2317
R769 gnd.t40 gnd.n505 32.2317
R770 gnd.n360 gnd.n359 31.3696
R771 gnd.n556 gnd.n51 28.9664
R772 gnd.n288 gnd.t9 28.9188
R773 gnd.n314 gnd.t38 28.9188
R774 gnd.n386 gnd.n154 28.2306
R775 gnd.n202 gnd.n147 28.2306
R776 gnd gnd.n411 26.7265
R777 gnd.n458 gnd.t3 26.5695
R778 gnd.n300 gnd.n190 26.5148
R779 gnd.n160 gnd.n158 25.908
R780 gnd.n421 gnd.n417 25.4353
R781 gnd.n422 gnd.n421 25.4353
R782 gnd.n535 gnd.n534 25.4353
R783 gnd.n536 gnd.n535 25.4353
R784 gnd.n534 gnd.n533 25.3599
R785 gnd.t1 gnd.t12 25.2428
R786 gnd.n349 gnd.n180 24.5662
R787 gnd.n428 gnd.n427 24.4034
R788 gnd.t76 gnd.t12 24.3368
R789 gnd.n387 gnd.n153 24.3368
R790 gnd.n198 gnd.n182 24.1052
R791 gnd.n556 gnd.n555 23.7398
R792 gnd.t25 gnd.n204 23.5273
R793 gnd.n411 gnd.n410 22.9299
R794 gnd.n390 gnd.n148 22.8576
R795 gnd.n235 gnd.n216 22.6843
R796 gnd.t36 gnd.t46 22.547
R797 gnd.n355 gnd.n353 21.5667
R798 gnd.n290 gnd.n223 21.5633
R799 gnd.t52 gnd.n470 21.3428
R800 gnd.t11 gnd.n522 21.3428
R801 gnd.n209 gnd.n208 21.1936
R802 gnd.n260 gnd.n229 21.0135
R803 gnd.n319 gnd.n208 20.9742
R804 gnd.n328 gnd.n327 20.8443
R805 gnd.n156 gnd.t28 20.6863
R806 gnd.n307 gnd.n294 20.6608
R807 gnd.n253 gnd.t47 20.5864
R808 gnd.n291 gnd.n290 20.447
R809 gnd.n250 gnd.n249 20.0963
R810 gnd.n403 gnd.t83 19.7236
R811 gnd.n351 gnd.n350 19.5694
R812 gnd.n406 gnd.n401 19.2752
R813 gnd.n534 gnd.n415 19.0561
R814 gnd.n350 gnd.n150 18.8637
R815 gnd.n329 gnd.n328 18.7229
R816 gnd.n396 gnd.n144 18.5842
R817 gnd.n299 gnd.n188 18.5384
R818 gnd.n401 gnd.n398 18.3609
R819 gnd.n381 gnd.n380 18.3129
R820 gnd.n49 gnd.n47 18.2817
R821 gnd.n402 gnd.n47 18.2817
R822 gnd.n539 gnd.n404 18.2817
R823 gnd.n458 gnd.n404 18.2817
R824 gnd.n411 gnd.n405 18.2817
R825 gnd.n458 gnd.n405 18.2817
R826 gnd.n548 gnd.n401 18.2817
R827 gnd.n548 gnd.n547 18.2817
R828 gnd.n407 gnd.n399 18.2817
R829 gnd.n547 gnd.n399 18.2817
R830 gnd.n316 gnd.n315 18.2817
R831 gnd.n315 gnd.n314 18.2817
R832 gnd.n245 gnd.n208 18.2817
R833 gnd.n246 gnd.n245 18.2817
R834 gnd.n233 gnd.n212 18.2817
R835 gnd.n313 gnd.n212 18.2817
R836 gnd.n260 gnd.n228 18.2817
R837 gnd.n228 gnd.n226 18.2817
R838 gnd.n328 gnd.n197 18.2817
R839 gnd.n303 gnd.n197 18.2817
R840 gnd.n199 gnd.n196 18.2817
R841 gnd.n303 gnd.n196 18.2817
R842 gnd.n348 gnd.n347 18.2817
R843 gnd.n347 gnd.n346 18.2817
R844 gnd.n345 gnd.n181 18.2817
R845 gnd.n346 gnd.n345 18.2817
R846 gnd.n312 gnd.n311 18.2817
R847 gnd.n313 gnd.n312 18.2817
R848 gnd.n235 gnd.n234 18.2817
R849 gnd.n234 gnd.n226 18.2817
R850 gnd.n224 gnd.n220 18.2817
R851 gnd.n224 gnd.n213 18.2817
R852 gnd.n290 gnd.n289 18.2817
R853 gnd.n289 gnd.n288 18.2817
R854 gnd.n305 gnd.n302 18.2817
R855 gnd.n305 gnd.n304 18.2817
R856 gnd.n297 gnd.n294 18.2817
R857 gnd.n304 gnd.n297 18.2817
R858 gnd.n338 gnd.n337 18.2817
R859 gnd.n337 gnd.n336 18.2817
R860 gnd.n335 gnd.n188 18.2817
R861 gnd.n336 gnd.n335 18.2817
R862 gnd.n376 gnd.n159 18.2817
R863 gnd.n376 gnd.n375 18.2817
R864 gnd.n375 gnd.n160 18.2817
R865 gnd.n350 gnd.n152 18.2817
R866 gnd.n162 gnd.n152 18.2817
R867 gnd.n151 gnd.n149 18.2817
R868 gnd.n162 gnd.n151 18.2817
R869 gnd.n396 gnd.n395 18.2817
R870 gnd.n395 gnd.n394 18.2817
R871 gnd.n393 gnd.n392 18.2817
R872 gnd.n394 gnd.n393 18.2817
R873 gnd.n384 gnd.n157 18.2817
R874 gnd.n157 gnd.n156 18.2817
R875 gnd.n380 gnd.n155 18.2817
R876 gnd.n156 gnd.n155 18.2817
R877 gnd.n564 gnd.n48 18.2817
R878 gnd.n402 gnd.n48 18.2817
R879 gnd.n562 gnd.n561 18.2817
R880 gnd.n561 gnd.n560 18.2817
R881 gnd.n559 gnd.n558 18.2817
R882 gnd.n560 gnd.n559 18.2817
R883 gnd gnd.n416 18.2491
R884 gnd.n55 gnd.n49 18.1135
R885 gnd.n565 gnd.n49 18.0922
R886 gnd.n120 gnd.n119 17.6613
R887 gnd.n459 gnd.n54 17.4008
R888 gnd.n318 gnd 17.2941
R889 gnd.n360 gnd.n178 17.1555
R890 gnd.t75 gnd.n353 17.1555
R891 gnd.n558 gnd.n557 16.5785
R892 gnd.n57 gnd.n56 15.8914
R893 gnd.n427 gnd.n417 15.0566
R894 gnd gnd.n351 14.7939
R895 gnd.n192 gnd.n167 14.5755
R896 gnd.n372 gnd.n371 14.3615
R897 gnd.n341 gnd.n188 13.5887
R898 gnd.n507 gnd 13.3666
R899 gnd.n334 gnd.n333 13.2343
R900 gnd.n193 gnd.n178 13.2343
R901 gnd gnd.n341 13.1589
R902 gnd.n470 gnd.n412 13.0672
R903 gnd.n569 gnd.n568 12.8987
R904 gnd.n322 gnd.n204 12.7442
R905 gnd.t35 gnd.t25 12.7442
R906 gnd.t7 gnd.t47 12.7442
R907 gnd.t46 gnd.t22 12.7442
R908 gnd.n249 gnd.n247 12.7442
R909 gnd.n455 gnd.n416 12.1951
R910 gnd gnd.n415 12.1951
R911 gnd gnd.t31 11.7362
R912 gnd.n410 gnd.n409 11.7068
R913 gnd.n55 gnd.n50 11.6949
R914 gnd gnd.n485 11.1792
R915 gnd.n540 gnd.n410 11.1397
R916 gnd.n351 gnd.n349 11.0638
R917 gnd.n374 gnd.t76 11.0287
R918 gnd.n474 gnd.n415 10.8276
R919 gnd.n599 gnd.n2 10.5357
R920 gnd.n550 gnd.n397 10.4204
R921 gnd.n300 gnd.n299 10.3256
R922 gnd gnd.n319 10.25
R923 gnd.t0 gnd.n424 10.0183
R924 gnd.n291 gnd.n222 10.0064
R925 gnd.n473 gnd.n446 9.67268
R926 gnd.n329 gnd.n182 9.42255
R927 gnd.n510 gnd.n509 9.3005
R928 gnd.n508 gnd.n507 9.3005
R929 gnd.n479 gnd.n478 9.3005
R930 gnd.n494 gnd.n487 9.14112
R931 gnd.n505 gnd.n487 9.14112
R932 gnd.n493 gnd.n486 9.14112
R933 gnd.n503 gnd.n486 9.14112
R934 gnd.n555 gnd.n59 8.83315
R935 gnd gnd.n77 8.83088
R936 gnd gnd.n77 8.83088
R937 gnd.n93 gnd 8.83088
R938 gnd gnd.n93 8.83088
R939 gnd gnd.n61 8.83088
R940 gnd gnd.n62 8.83088
R941 gnd gnd.n62 8.83088
R942 gnd gnd.n120 8.83088
R943 gnd.n537 gnd.n536 8.71165
R944 gnd.n532 gnd.n417 8.65662
R945 gnd gnd.n167 8.60103
R946 gnd.n288 gnd.n226 8.33291
R947 gnd.t68 gnd.t38 8.33291
R948 gnd.n313 gnd.n213 8.33291
R949 gnd.n193 gnd.t64 8.33291
R950 gnd gnd.t39 7.62538
R951 gnd gnd.t70 7.62538
R952 gnd gnd.t69 7.62538
R953 gnd gnd.t10 7.62538
R954 gnd gnd.t51 7.62538
R955 gnd gnd.t49 7.62538
R956 gnd gnd.t77 7.62538
R957 gnd gnd.t29 7.62538
R958 gnd gnd.t59 7.62538
R959 gnd gnd.t82 7.62538
R960 gnd.n336 gnd.t17 7.59769
R961 gnd.n346 gnd.t48 7.59769
R962 gnd.n375 gnd.t12 7.59769
R963 gnd.n156 gnd.t84 7.54475
R964 gnd.n394 gnd.t28 7.54475
R965 gnd.n520 gnd.n431 7.41275
R966 gnd.n253 gnd.t35 7.35262
R967 gnd.n359 gnd.t75 7.35262
R968 gnd.n342 gnd 7.32225
R969 gnd.n241 gnd 7.30415
R970 gnd.n308 gnd.n307 7.21559
R971 gnd.n327 gnd 7.0696
R972 gnd.n237 gnd.n207 7.0405
R973 gnd gnd.n286 7.03742
R974 gnd.n231 gnd.n230 6.99633
R975 gnd.n243 gnd.n242 6.90017
R976 gnd gnd.n296 6.87941
R977 gnd.n520 gnd.n519 6.85764
R978 gnd.n308 gnd.n293 6.81181
R979 gnd.t81 gnd.n458 6.75164
R980 gnd.n317 gnd 6.72991
R981 gnd.n248 gnd.n231 6.72464
R982 gnd.n249 gnd.n248 6.72464
R983 gnd.n321 gnd.n320 6.72464
R984 gnd.n322 gnd.n321 6.72464
R985 gnd.n281 gnd.n278 6.72464
R986 gnd.n281 gnd.n280 6.72464
R987 gnd.n286 gnd.n285 6.72464
R988 gnd.n285 gnd.n284 6.72464
R989 gnd.n244 gnd.n243 6.72464
R990 gnd.n247 gnd.n244 6.72464
R991 gnd.n240 gnd.n239 6.72464
R992 gnd.n240 gnd.n204 6.72464
R993 gnd.n295 gnd.n219 6.72464
R994 gnd.n279 gnd.n219 6.72464
R995 gnd.n241 gnd.n218 6.72464
R996 gnd.n283 gnd.n218 6.72464
R997 gnd.n304 gnd.t50 6.61741
R998 gnd gnd.n200 6.56673
R999 gnd.n119 gnd 6.4005
R1000 gnd.n252 gnd.n238 6.39615
R1001 gnd.n128 gnd.n61 6.35999
R1002 gnd gnd.n435 6.30002
R1003 gnd gnd.n532 6.29814
R1004 gnd.n60 gnd 6.2354
R1005 gnd.n379 gnd.n378 6.22395
R1006 gnd.n455 gnd.n454 6.17761
R1007 gnd.n364 gnd.n363 6.17309
R1008 gnd.n465 gnd.n455 6.14801
R1009 gnd.n307 gnd 6.13928
R1010 gnd.n363 gnd.n174 6.11056
R1011 gnd.n252 gnd.n207 6.09435
R1012 gnd.n402 gnd.t57 6.05411
R1013 gnd.n547 gnd.t58 6.05411
R1014 gnd.n390 gnd.n389 6.02403
R1015 gnd.n563 gnd 6.02403
R1016 gnd.n58 gnd.n51 6.02403
R1017 gnd.n438 gnd.n59 5.96989
R1018 gnd.t11 gnd.n438 5.96989
R1019 gnd.n524 gnd.n523 5.96989
R1020 gnd.n523 gnd.t11 5.96989
R1021 gnd.n489 gnd.n440 5.8876
R1022 gnd.n327 gnd 5.88547
R1023 gnd.n375 gnd.n374 5.8822
R1024 gnd.n481 gnd 5.72331
R1025 gnd.n336 gnd.t48 5.63713
R1026 gnd.n1 gnd 5.56562
R1027 gnd.n319 gnd.n318 5.54505
R1028 gnd.n263 gnd 5.53813
R1029 gnd.n134 gnd 5.52988
R1030 gnd.n136 gnd 5.52988
R1031 gnd.n137 gnd 5.52988
R1032 gnd.n138 gnd 5.52988
R1033 gnd.n139 gnd 5.52988
R1034 gnd.n60 gnd 5.52988
R1035 gnd.n130 gnd 5.52988
R1036 gnd.n131 gnd 5.52988
R1037 gnd.n132 gnd 5.52988
R1038 gnd.n133 gnd 5.52988
R1039 gnd.n258 gnd 5.52172
R1040 gnd.n258 gnd.n238 5.52172
R1041 gnd.n0 gnd 5.50872
R1042 gnd.t7 gnd.t36 5.39206
R1043 gnd.n292 gnd.n291 5.37026
R1044 gnd.t76 gnd.n162 4.99837
R1045 gnd.n271 gnd 4.94755
R1046 gnd.n475 gnd 4.92436
R1047 gnd gnd.n190 4.89462
R1048 gnd.n330 gnd.n198 4.89462
R1049 gnd.n460 gnd.n459 4.84001
R1050 gnd.n410 gnd.n406 4.61482
R1051 gnd.n340 gnd.n189 4.46064
R1052 gnd gnd.n524 4.30722
R1053 gnd gnd.n217 4.26717
R1054 gnd.n203 gnd.n202 4.13767
R1055 gnd.n572 gnd.n31 3.97543
R1056 gnd.n476 gnd 3.88429
R1057 gnd.n391 gnd 3.76521
R1058 gnd gnd.n416 3.71687
R1059 gnd.n492 gnd.n491 3.68422
R1060 gnd.n276 gnd.n275 3.66929
R1061 gnd.n532 gnd 3.64225
R1062 gnd.n495 gnd.n485 3.58958
R1063 gnd.n274 gnd.n273 3.55515
R1064 gnd.n491 gnd.n444 3.47337
R1065 gnd.n258 gnd 3.47127
R1066 gnd.t22 gnd.n250 3.43149
R1067 gnd.n189 gnd 3.42198
R1068 gnd.n463 gnd.n462 3.38874
R1069 gnd.t83 gnd.n54 3.19269
R1070 gnd.n381 gnd.n379 3.10722
R1071 gnd.n497 gnd.n494 3.06551
R1072 gnd.n261 gnd.n259 3.02835
R1073 gnd.n510 gnd.n444 2.79857
R1074 gnd gnd.n510 2.74446
R1075 gnd.n533 gnd.n416 2.65397
R1076 gnd.n524 gnd.n435 2.60533
R1077 gnd.n128 gnd 2.47139
R1078 gnd.n284 gnd.n283 2.45121
R1079 gnd.t16 gnd.t42 2.45121
R1080 gnd.t21 gnd.t80 2.45121
R1081 gnd.t60 gnd.t61 2.45121
R1082 gnd.n280 gnd.n279 2.45121
R1083 gnd.n560 gnd.n54 2.41933
R1084 gnd gnd.n418 2.34932
R1085 gnd.n552 gnd.n551 2.27523
R1086 gnd.n558 gnd.n57 2.14323
R1087 gnd.n512 gnd.n440 2.124
R1088 gnd.n318 gnd.n317 2.07109
R1089 gnd.n275 gnd.n274 2.00611
R1090 gnd.n598 gnd 1.98796
R1091 gnd gnd.n4 1.98796
R1092 gnd gnd.n4 1.98796
R1093 gnd gnd.n590 1.98796
R1094 gnd.n590 gnd 1.98796
R1095 gnd gnd.n18 1.98796
R1096 gnd gnd.n582 1.98796
R1097 gnd.n582 gnd 1.98796
R1098 gnd gnd.n31 1.98796
R1099 gnd gnd.n553 1.96431
R1100 gnd.n478 gnd.n418 1.93989
R1101 gnd.n293 gnd.n292 1.92544
R1102 gnd gnd.n435 1.89346
R1103 gnd gnd.n237 1.82204
R1104 gnd.n507 gnd.n444 1.80147
R1105 gnd.n264 gnd.n263 1.77059
R1106 gnd gnd.n179 1.67919
R1107 gnd.n341 gnd.n340 1.6005
R1108 gnd.n474 gnd.n473 1.58847
R1109 gnd.n483 gnd.n482 1.5505
R1110 gnd.n246 gnd.n226 1.47092
R1111 gnd.t9 gnd.t68 1.47092
R1112 gnd.n314 gnd.n313 1.47092
R1113 gnd.n554 gnd 1.45192
R1114 gnd.n572 gnd 1.44096
R1115 gnd gnd.n40 1.44096
R1116 gnd.n28 gnd.n18 1.43184
R1117 gnd.n372 gnd.n165 1.32733
R1118 gnd.n265 gnd.n264 1.32145
R1119 gnd.n270 gnd.n269 1.30607
R1120 gnd.n180 gnd.n179 1.29343
R1121 gnd.n457 gnd 1.19155
R1122 gnd.n269 gnd.n268 1.10513
R1123 gnd.n477 gnd.n475 1.06682
R1124 gnd.n325 gnd.n201 0.980783
R1125 gnd.t50 gnd.t18 0.980783
R1126 gnd.n304 gnd.n303 0.980783
R1127 gnd.n332 gnd.n195 0.980783
R1128 gnd.n167 gnd.n158 0.974778
R1129 gnd.n273 gnd.n261 0.807634
R1130 gnd gnd.n600 0.770152
R1131 gnd.n140 gnd 0.7355
R1132 gnd.n339 gnd 0.711611
R1133 gnd.n272 gnd.n265 0.698206
R1134 gnd.n266 gnd.n142 0.680903
R1135 gnd.n553 gnd.n552 0.662588
R1136 gnd.n271 gnd.n270 0.61827
R1137 gnd.n554 gnd.n141 0.617121
R1138 gnd.n268 gnd.n267 0.59528
R1139 gnd.n141 gnd.n140 0.588384
R1140 gnd.n267 gnd.n266 0.563687
R1141 gnd gnd.n28 0.556625
R1142 gnd.n600 gnd.n1 0.53686
R1143 gnd.n150 gnd.n148 0.522532
R1144 gnd.n460 gnd.t81 0.515789
R1145 gnd.n497 gnd.n496 0.498883
R1146 gnd.n475 gnd 0.489974
R1147 gnd gnd.n477 0.478714
R1148 gnd.n551 gnd.n142 0.467075
R1149 gnd.n243 gnd.n241 0.447012
R1150 gnd.n266 gnd 0.396445
R1151 gnd gnd.n434 0.388379
R1152 gnd.n563 gnd.n50 0.383224
R1153 gnd.n481 gnd.n480 0.380169
R1154 gnd.n142 gnd 0.362448
R1155 gnd.n552 gnd 0.361897
R1156 gnd.n553 gnd 0.351827
R1157 gnd.n268 gnd 0.340773
R1158 gnd.n496 gnd.n495 0.328085
R1159 gnd.n267 gnd 0.326793
R1160 gnd.n477 gnd.n476 0.322643
R1161 gnd.n269 gnd 0.32119
R1162 gnd.n270 gnd 0.32119
R1163 gnd.n265 gnd 0.32119
R1164 gnd.n264 gnd 0.32119
R1165 gnd.n476 gnd.n141 0.289251
R1166 gnd.n131 gnd.n130 0.272888
R1167 gnd.n132 gnd.n131 0.271022
R1168 gnd.n148 gnd.n144 0.269142
R1169 gnd.n56 gnd.n55 0.26522
R1170 gnd.n363 gnd 0.260166
R1171 gnd.n391 gnd.n390 0.249851
R1172 gnd.n557 gnd.n556 0.240148
R1173 gnd.n129 gnd.n128 0.233
R1174 gnd.n135 gnd.n28 0.233
R1175 gnd gnd.n474 0.22119
R1176 gnd.n371 gnd.n370 0.202075
R1177 gnd.n133 gnd.n132 0.197639
R1178 gnd gnd.n398 0.194094
R1179 gnd gnd.n565 0.192049
R1180 gnd.n192 gnd 0.19013
R1181 gnd gnd.n223 0.181231
R1182 gnd.n242 gnd.n216 0.181231
R1183 gnd gnd.n229 0.175139
R1184 gnd.n230 gnd.n209 0.175139
R1185 gnd.n129 gnd.n60 0.169654
R1186 gnd.n262 gnd.n189 0.166571
R1187 gnd.n134 gnd.n1 0.162894
R1188 gnd.n509 gnd.n481 0.160845
R1189 gnd.n277 gnd.n276 0.147252
R1190 gnd.n259 gnd.n258 0.137512
R1191 gnd.n509 gnd.n508 0.128733
R1192 gnd.n457 gnd.n456 0.128651
R1193 gnd.n409 gnd.n408 0.122019
R1194 gnd gnd.n0 0.105344
R1195 gnd.n130 gnd.n129 0.10249
R1196 gnd.n263 gnd.n262 0.0981562
R1197 gnd.n508 gnd.n483 0.0896027
R1198 gnd.n370 gnd 0.0844895
R1199 gnd.n286 gnd.n231 0.082683
R1200 gnd gnd.n133 0.0776144
R1201 gnd.n137 gnd.n136 0.0665434
R1202 gnd.n138 gnd.n137 0.0660911
R1203 gnd.n496 gnd.n483 0.0623534
R1204 gnd.n340 gnd.n167 0.0615978
R1205 gnd.n140 gnd 0.0604793
R1206 gnd.n139 gnd.n138 0.0482986
R1207 gnd.n555 gnd.n554 0.0447857
R1208 gnd.n135 gnd.n134 0.0415133
R1209 gnd gnd.n0 0.0400312
R1210 gnd.n272 gnd.n271 0.0386098
R1211 gnd.n480 gnd.n434 0.0299304
R1212 gnd.n136 gnd.n135 0.0252286
R1213 gnd.n273 gnd.n272 0.0242245
R1214 gnd.n479 gnd 0.0237143
R1215 gnd.n478 gnd.n434 0.0220488
R1216 gnd.n262 gnd 0.01925
R1217 gnd gnd.n139 0.0191972
R1218 gnd.n551 gnd.n550 0.00525703
R1219 gnd.n600 gnd.n599 0.00450517
R1220 gnd.n480 gnd.n479 0.00121429
R1221 x5.sky130_fd_pr__cap_mim_m3_2_SLGBQV_2.C2 x5.sky130_fd_pr__cap_mim_m3_2_SLGBQV_2.C2.t0 7.62538
R1222 x5.Phi_2 x5.Phi_2.t5 3310.71
R1223 x5.Phi_2 x5.Phi_2.t4 1898.45
R1224 x5.Phi_2 x5.Phi_2.t3 466.908
R1225 x5.Phi_2 x5.Phi_2.t6 331.947
R1226 x5.Phi_2 x5.Phi_2.t2 165.293
R1227 x5.Phi_2 x5.Phi_2.t1 165.293
R1228 x5.Phi_2 x5.Phi_2.t0 115.701
R1229 x5.Phi_2.n0 x5.Phi_2 18.0893
R1230 x5.Phi_2.n0 x5.Phi_2 18.063
R1231 x5.Phi_2.n4 x5.Phi_2 10.758
R1232 x5.Phi_2.n2 x5.Phi_2 9.71186
R1233 x5.Phi_2.n2 x5.Phi_2 9.68056
R1234 x5.Phi_2.n5 x5.Phi_2.n4 5.43161
R1235 x5.Phi_2.n3 x5.Phi_2.n2 4.5005
R1236 x5.Phi_2.n1 x5.Phi_2 3.05865
R1237 x5.Phi_2.n5 x5.Phi_2 2.3255
R1238 x5.Phi_2 x5.Phi_2.n5 2.3255
R1239 x5.Phi_2 x5.Phi_2.n0 1.03677
R1240 x5.Phi_2.n4 x5.Phi_2.n3 0.998897
R1241 x5.Phi_2.n1 x5.Phi_2 0.964841
R1242 x5.Phi_2.n3 x5.Phi_2.n1 0.947973
R1243 Vdd.n308 Vdd.n306 7736.47
R1244 Vdd.n315 Vdd.n301 7736.47
R1245 Vdd.n284 Vdd.n282 7736.47
R1246 Vdd.n294 Vdd.n278 7736.47
R1247 Vdd.n310 Vdd.n303 7178.82
R1248 Vdd.n310 Vdd.n300 7178.82
R1249 Vdd.n290 Vdd.n277 7178.82
R1250 Vdd.n290 Vdd.n280 7178.82
R1251 Vdd.n170 Vdd.n168 3942.35
R1252 Vdd.n173 Vdd.n172 3942.35
R1253 Vdd.n177 Vdd.n165 3942.35
R1254 Vdd.n180 Vdd.n164 3942.35
R1255 Vdd.n157 Vdd.n156 3942.35
R1256 Vdd.n184 Vdd.n130 3942.35
R1257 Vdd.n132 Vdd.n129 3172.94
R1258 Vdd.n133 Vdd.n132 3172.94
R1259 Vdd.n142 Vdd.n139 2018.82
R1260 Vdd.n145 Vdd.n138 2018.82
R1261 Vdd.n222 Vdd.n218 1877.65
R1262 Vdd.n76 Vdd.n72 1877.65
R1263 Vdd.n249 Vdd.n247 1665.88
R1264 Vdd.n103 Vdd.n101 1665.88
R1265 Vdd.n325 Vdd.n324 1665.88
R1266 Vdd.n322 Vdd.n319 1665.88
R1267 Vdd.n152 Vdd.n135 1489.41
R1268 Vdd.n149 Vdd.n148 1489.41
R1269 Vdd.n38 Vdd.n4 1489.41
R1270 Vdd.n14 Vdd.n13 1489.41
R1271 Vdd.n29 Vdd.n17 1489.41
R1272 Vdd.n22 Vdd.n20 1489.41
R1273 Vdd.n238 Vdd.n237 1108.24
R1274 Vdd.n238 Vdd.n235 1108.24
R1275 Vdd.n232 Vdd.n198 1108.24
R1276 Vdd.n232 Vdd.n202 1108.24
R1277 Vdd.n203 Vdd.n197 1108.24
R1278 Vdd.n203 Vdd.n201 1108.24
R1279 Vdd.n209 Vdd.n208 1108.24
R1280 Vdd.n209 Vdd.n206 1108.24
R1281 Vdd.n215 Vdd.n212 1108.24
R1282 Vdd.n215 Vdd.n214 1108.24
R1283 Vdd.n244 Vdd.n241 1108.24
R1284 Vdd.n244 Vdd.n243 1108.24
R1285 Vdd.n92 Vdd.n91 1108.24
R1286 Vdd.n92 Vdd.n89 1108.24
R1287 Vdd.n86 Vdd.n52 1108.24
R1288 Vdd.n86 Vdd.n56 1108.24
R1289 Vdd.n57 Vdd.n51 1108.24
R1290 Vdd.n57 Vdd.n55 1108.24
R1291 Vdd.n63 Vdd.n62 1108.24
R1292 Vdd.n63 Vdd.n60 1108.24
R1293 Vdd.n69 Vdd.n66 1108.24
R1294 Vdd.n69 Vdd.n68 1108.24
R1295 Vdd.n98 Vdd.n95 1108.24
R1296 Vdd.n98 Vdd.n97 1108.24
R1297 Vdd.n35 Vdd.n6 931.765
R1298 Vdd.n35 Vdd.n7 931.765
R1299 Vdd.n28 Vdd.n27 931.765
R1300 Vdd.n27 Vdd.n16 931.765
R1301 Vdd.n220 Vdd.n212 769.413
R1302 Vdd.n225 Vdd.n212 769.413
R1303 Vdd.n225 Vdd.n208 769.413
R1304 Vdd.n229 Vdd.n208 769.413
R1305 Vdd.n229 Vdd.n197 769.413
R1306 Vdd.n262 Vdd.n197 769.413
R1307 Vdd.n262 Vdd.n198 769.413
R1308 Vdd.n258 Vdd.n198 769.413
R1309 Vdd.n258 Vdd.n237 769.413
R1310 Vdd.n254 Vdd.n237 769.413
R1311 Vdd.n254 Vdd.n241 769.413
R1312 Vdd.n222 Vdd.n214 769.413
R1313 Vdd.n224 Vdd.n214 769.413
R1314 Vdd.n224 Vdd.n206 769.413
R1315 Vdd.n230 Vdd.n206 769.413
R1316 Vdd.n230 Vdd.n201 769.413
R1317 Vdd.n261 Vdd.n201 769.413
R1318 Vdd.n261 Vdd.n202 769.413
R1319 Vdd.n259 Vdd.n202 769.413
R1320 Vdd.n259 Vdd.n235 769.413
R1321 Vdd.n253 Vdd.n235 769.413
R1322 Vdd.n253 Vdd.n243 769.413
R1323 Vdd.n157 Vdd.n129 769.413
R1324 Vdd.n184 Vdd.n129 769.413
R1325 Vdd.n159 Vdd.n133 769.413
R1326 Vdd.n182 Vdd.n133 769.413
R1327 Vdd.n74 Vdd.n66 769.413
R1328 Vdd.n79 Vdd.n66 769.413
R1329 Vdd.n79 Vdd.n62 769.413
R1330 Vdd.n83 Vdd.n62 769.413
R1331 Vdd.n83 Vdd.n51 769.413
R1332 Vdd.n116 Vdd.n51 769.413
R1333 Vdd.n116 Vdd.n52 769.413
R1334 Vdd.n112 Vdd.n52 769.413
R1335 Vdd.n112 Vdd.n91 769.413
R1336 Vdd.n108 Vdd.n91 769.413
R1337 Vdd.n108 Vdd.n95 769.413
R1338 Vdd.n76 Vdd.n68 769.413
R1339 Vdd.n78 Vdd.n68 769.413
R1340 Vdd.n78 Vdd.n60 769.413
R1341 Vdd.n84 Vdd.n60 769.413
R1342 Vdd.n84 Vdd.n55 769.413
R1343 Vdd.n115 Vdd.n55 769.413
R1344 Vdd.n115 Vdd.n56 769.413
R1345 Vdd.n113 Vdd.n56 769.413
R1346 Vdd.n113 Vdd.n89 769.413
R1347 Vdd.n107 Vdd.n89 769.413
R1348 Vdd.n107 Vdd.n97 769.413
R1349 Vdd.n312 Vdd.n311 765.741
R1350 Vdd.n311 Vdd.n298 765.741
R1351 Vdd.n291 Vdd.n276 765.741
R1352 Vdd.n292 Vdd.n291 765.741
R1353 Vdd.n249 Vdd.n241 557.648
R1354 Vdd.n251 Vdd.n243 557.648
R1355 Vdd.n103 Vdd.n95 557.648
R1356 Vdd.n105 Vdd.n97 557.648
R1357 Vdd.n11 Vdd.n6 557.648
R1358 Vdd.n6 Vdd.n4 557.648
R1359 Vdd.n14 Vdd.n7 557.648
R1360 Vdd.n7 Vdd.n5 557.648
R1361 Vdd.n29 Vdd.n28 557.648
R1362 Vdd.n28 Vdd.n19 557.648
R1363 Vdd.n31 Vdd.n16 557.648
R1364 Vdd.n20 Vdd.n16 557.648
R1365 Vdd.n317 Vdd.n300 557.648
R1366 Vdd.n300 Vdd.n299 557.648
R1367 Vdd.n315 Vdd.n303 557.648
R1368 Vdd.n308 Vdd.n303 557.648
R1369 Vdd.n277 Vdd.n275 557.648
R1370 Vdd.n296 Vdd.n277 557.648
R1371 Vdd.n284 Vdd.n280 557.648
R1372 Vdd.n294 Vdd.n280 557.648
R1373 Vdd.n186 Vdd.n127 338.447
R1374 Vdd.n160 Vdd.n127 338.447
R1375 Vdd.t22 Vdd.n213 269.661
R1376 Vdd.t2 Vdd.n213 269.661
R1377 Vdd.t2 Vdd.n207 269.661
R1378 Vdd.t40 Vdd.n207 269.661
R1379 Vdd.t40 Vdd.n199 269.661
R1380 Vdd.t36 Vdd.n199 269.661
R1381 Vdd.t36 Vdd.n200 269.661
R1382 Vdd.t52 Vdd.n200 269.661
R1383 Vdd.t52 Vdd.n236 269.661
R1384 Vdd.t46 Vdd.n236 269.661
R1385 Vdd.t46 Vdd.n242 269.661
R1386 Vdd.t56 Vdd.n67 269.661
R1387 Vdd.t26 Vdd.n67 269.661
R1388 Vdd.t26 Vdd.n61 269.661
R1389 Vdd.t28 Vdd.n61 269.661
R1390 Vdd.t28 Vdd.n53 269.661
R1391 Vdd.t14 Vdd.n53 269.661
R1392 Vdd.t14 Vdd.n54 269.661
R1393 Vdd.t54 Vdd.n54 269.661
R1394 Vdd.t54 Vdd.n90 269.661
R1395 Vdd.t16 Vdd.n90 269.661
R1396 Vdd.t16 Vdd.n96 269.661
R1397 Vdd.n221 Vdd.n218 250.431
R1398 Vdd.n75 Vdd.n72 250.431
R1399 Vdd.n36 Vdd.t38 224.702
R1400 Vdd.t50 Vdd.n36 224.702
R1401 Vdd.t12 Vdd.n18 224.702
R1402 Vdd.t44 Vdd.n18 224.702
R1403 Vdd.n13 Vdd.n12 207.133
R1404 Vdd.n22 Vdd.n21 207.133
R1405 Vdd.n150 Vdd.n135 207.133
R1406 Vdd.n151 Vdd.n148 207.133
R1407 Vdd.n38 Vdd.n37 207.133
R1408 Vdd.n30 Vdd.n17 207.133
R1409 Vdd Vdd.n217 200.282
R1410 Vdd Vdd.n71 200.282
R1411 Vdd.t30 Vdd.n242 195.444
R1412 Vdd.t6 Vdd.n96 195.444
R1413 Vdd.n250 Vdd.n247 186.649
R1414 Vdd.n104 Vdd.n101 186.649
R1415 Vdd.n325 Vdd.n274 186.649
R1416 Vdd.n323 Vdd.n322 186.649
R1417 Vdd Vdd.n246 177.946
R1418 Vdd Vdd.n100 177.946
R1419 Vdd Vdd.t35 165.293
R1420 Vdd Vdd.t45 165.293
R1421 Vdd Vdd.t13 165.293
R1422 Vdd Vdd.t51 165.293
R1423 Vdd Vdd.t39 165.293
R1424 Vdd.n143 Vdd.n142 153.352
R1425 Vdd.n145 Vdd.n144 153.352
R1426 Vdd Vdd.n293 140.971
R1427 Vdd.n293 Vdd.n276 137.028
R1428 Vdd.n309 Vdd.n305 126.751
R1429 Vdd.n219 Vdd.n217 125.555
R1430 Vdd.n73 Vdd.n71 125.555
R1431 Vdd.n248 Vdd.n246 124.376
R1432 Vdd.n102 Vdd.n100 124.376
R1433 Vdd.n305 Vdd.n298 122.808
R1434 Vdd.n245 Vdd.n240 118.213
R1435 Vdd.n252 Vdd.n245 118.213
R1436 Vdd.n256 Vdd.n239 118.213
R1437 Vdd.n239 Vdd.n234 118.213
R1438 Vdd.n233 Vdd.n196 118.213
R1439 Vdd.n260 Vdd.n233 118.213
R1440 Vdd.n204 Vdd.n195 118.213
R1441 Vdd.n231 Vdd.n204 118.213
R1442 Vdd.n227 Vdd.n210 118.213
R1443 Vdd.n210 Vdd.n205 118.213
R1444 Vdd.n216 Vdd.n211 118.213
R1445 Vdd.n223 Vdd.n216 118.213
R1446 Vdd.n99 Vdd.n94 118.213
R1447 Vdd.n106 Vdd.n99 118.213
R1448 Vdd.n110 Vdd.n93 118.213
R1449 Vdd.n93 Vdd.n88 118.213
R1450 Vdd.n87 Vdd.n50 118.213
R1451 Vdd.n114 Vdd.n87 118.213
R1452 Vdd.n58 Vdd.n49 118.213
R1453 Vdd.n85 Vdd.n58 118.213
R1454 Vdd.n81 Vdd.n64 118.213
R1455 Vdd.n64 Vdd.n59 118.213
R1456 Vdd.n70 Vdd.n65 118.213
R1457 Vdd.n77 Vdd.n70 118.213
R1458 Vdd Vdd.t31 111.784
R1459 Vdd Vdd.t47 111.784
R1460 Vdd Vdd.t53 111.784
R1461 Vdd Vdd.t37 111.784
R1462 Vdd Vdd.t41 111.784
R1463 Vdd Vdd.t3 111.784
R1464 Vdd Vdd.t23 111.784
R1465 Vdd Vdd.t7 111.784
R1466 Vdd Vdd.t17 111.784
R1467 Vdd Vdd.t55 111.784
R1468 Vdd Vdd.t15 111.784
R1469 Vdd Vdd.t29 111.784
R1470 Vdd Vdd.t27 111.784
R1471 Vdd Vdd.t57 111.784
R1472 Vdd Vdd.t5 111.784
R1473 Vdd.n158 Vdd.n156 109.793
R1474 Vdd.n183 Vdd.n130 109.793
R1475 Vdd.n171 Vdd.n170 109.793
R1476 Vdd.n173 Vdd.n167 109.793
R1477 Vdd.n179 Vdd.n165 109.793
R1478 Vdd.n178 Vdd.n164 109.793
R1479 Vdd.t24 Vdd.n131 106.864
R1480 Vdd.t10 Vdd.n131 106.864
R1481 Vdd.n169 Vdd 104.981
R1482 Vdd.n34 Vdd.n33 99.3887
R1483 Vdd.n26 Vdd.n25 99.3887
R1484 Vdd.n26 Vdd.n15 99.3887
R1485 Vdd.n34 Vdd.n8 98.6358
R1486 Vdd Vdd.n251 92.5005
R1487 Vdd.n249 Vdd.n248 92.5005
R1488 Vdd.t30 Vdd.n249 92.5005
R1489 Vdd Vdd.n139 92.5005
R1490 Vdd.n140 Vdd.n138 92.5005
R1491 Vdd.n149 Vdd.n134 92.5005
R1492 Vdd Vdd.n152 92.5005
R1493 Vdd Vdd.n105 92.5005
R1494 Vdd.n103 Vdd.n102 92.5005
R1495 Vdd.t6 Vdd.n103 92.5005
R1496 Vdd.n11 Vdd.n10 92.5005
R1497 Vdd.n4 Vdd.n1 92.5005
R1498 Vdd.t50 Vdd.n4 92.5005
R1499 Vdd Vdd.n5 92.5005
R1500 Vdd Vdd.n14 92.5005
R1501 Vdd.n14 Vdd.t38 92.5005
R1502 Vdd.n29 Vdd.n2 92.5005
R1503 Vdd.t12 Vdd.n29 92.5005
R1504 Vdd.n24 Vdd.n19 92.5005
R1505 Vdd.n20 Vdd 92.5005
R1506 Vdd.t44 Vdd.n20 92.5005
R1507 Vdd Vdd.n31 92.5005
R1508 Vdd.n315 Vdd.n314 92.5005
R1509 Vdd.t20 Vdd.n315 92.5005
R1510 Vdd.n309 Vdd.n308 92.5005
R1511 Vdd.n308 Vdd.t48 92.5005
R1512 Vdd Vdd.n299 92.5005
R1513 Vdd Vdd.n317 92.5005
R1514 Vdd.n319 Vdd.n318 92.5005
R1515 Vdd.n294 Vdd 92.5005
R1516 Vdd.t8 Vdd.n294 92.5005
R1517 Vdd Vdd.n284 92.5005
R1518 Vdd.n284 Vdd.t18 92.5005
R1519 Vdd.n297 Vdd.n275 92.5005
R1520 Vdd.n297 Vdd.n296 92.5005
R1521 Vdd.n324 Vdd 92.5005
R1522 Vdd.n307 Vdd.n299 90.9566
R1523 Vdd.n317 Vdd.n316 90.9566
R1524 Vdd.n283 Vdd.n275 90.9566
R1525 Vdd.n296 Vdd.n295 90.9566
R1526 Vdd Vdd.n154 86.3225
R1527 Vdd Vdd.t33 82.6472
R1528 Vdd.n223 Vdd 82.0711
R1529 Vdd Vdd.n223 82.0711
R1530 Vdd Vdd.n205 82.0711
R1531 Vdd Vdd.n205 82.0711
R1532 Vdd.n231 Vdd 82.0711
R1533 Vdd Vdd.n231 82.0711
R1534 Vdd Vdd.n260 82.0711
R1535 Vdd.n260 Vdd 82.0711
R1536 Vdd Vdd.n234 82.0711
R1537 Vdd Vdd.n234 82.0711
R1538 Vdd Vdd.n252 82.0711
R1539 Vdd.n160 Vdd 82.0711
R1540 Vdd Vdd.n160 82.0711
R1541 Vdd.n77 Vdd 82.0711
R1542 Vdd Vdd.n77 82.0711
R1543 Vdd Vdd.n59 82.0711
R1544 Vdd Vdd.n59 82.0711
R1545 Vdd.n85 Vdd 82.0711
R1546 Vdd Vdd.n85 82.0711
R1547 Vdd Vdd.n114 82.0711
R1548 Vdd.n114 Vdd 82.0711
R1549 Vdd Vdd.n88 82.0711
R1550 Vdd Vdd.n88 82.0711
R1551 Vdd Vdd.n106 82.0711
R1552 Vdd.n144 Vdd.n139 81.7299
R1553 Vdd.n143 Vdd.n138 81.7299
R1554 Vdd.n23 Vdd 80.8658
R1555 Vdd.n251 Vdd.n250 77.8163
R1556 Vdd.n105 Vdd.n104 77.8163
R1557 Vdd.n319 Vdd.n274 77.8163
R1558 Vdd.n324 Vdd.n323 77.8163
R1559 Vdd.n181 Vdd 75.701
R1560 Vdd Vdd.n163 75.6711
R1561 Vdd Vdd.n163 75.6711
R1562 Vdd Vdd.n181 75.6711
R1563 Vdd.n12 Vdd.n11 74.9804
R1564 Vdd.n21 Vdd.n19 74.9804
R1565 Vdd.n150 Vdd.n149 74.9804
R1566 Vdd.n152 Vdd.n151 74.9804
R1567 Vdd.n37 Vdd.n5 74.9804
R1568 Vdd.n31 Vdd.n30 74.9804
R1569 Vdd.n141 Vdd 66.064
R1570 Vdd.n314 Vdd.n304 64.1849
R1571 Vdd Vdd.n9 63.7243
R1572 Vdd Vdd.n281 61.8976
R1573 Vdd.n252 Vdd 59.4829
R1574 Vdd.n106 Vdd 59.4829
R1575 Vdd.n33 Vdd 59.4829
R1576 Vdd.n33 Vdd 59.4829
R1577 Vdd Vdd.n15 59.4829
R1578 Vdd Vdd.n15 59.4829
R1579 Vdd.n304 Vdd.n298 58.3754
R1580 Vdd.n281 Vdd.n276 55.6313
R1581 Vdd.n153 Vdd 53.4705
R1582 Vdd.n32 Vdd 53.1125
R1583 Vdd Vdd.n136 53.0829
R1584 Vdd Vdd.n32 53.0829
R1585 Vdd Vdd.n136 48.5652
R1586 Vdd.n253 Vdd 46.2505
R1587 Vdd.t46 Vdd.n253 46.2505
R1588 Vdd Vdd.n259 46.2505
R1589 Vdd.n259 Vdd.t52 46.2505
R1590 Vdd.n261 Vdd 46.2505
R1591 Vdd.t36 Vdd.n261 46.2505
R1592 Vdd Vdd.n230 46.2505
R1593 Vdd.n230 Vdd.t40 46.2505
R1594 Vdd.n224 Vdd 46.2505
R1595 Vdd.t2 Vdd.n224 46.2505
R1596 Vdd Vdd.n222 46.2505
R1597 Vdd.n222 Vdd.t22 46.2505
R1598 Vdd.n220 Vdd.n219 46.2505
R1599 Vdd.n226 Vdd.n225 46.2505
R1600 Vdd.n225 Vdd.t2 46.2505
R1601 Vdd.n229 Vdd.n228 46.2505
R1602 Vdd.t40 Vdd.n229 46.2505
R1603 Vdd.n263 Vdd.n262 46.2505
R1604 Vdd.n262 Vdd.t36 46.2505
R1605 Vdd.n258 Vdd.n257 46.2505
R1606 Vdd.t52 Vdd.n258 46.2505
R1607 Vdd.n255 Vdd.n254 46.2505
R1608 Vdd.n254 Vdd.t46 46.2505
R1609 Vdd.n177 Vdd.n176 46.2505
R1610 Vdd.n168 Vdd.n166 46.2505
R1611 Vdd.n172 Vdd 46.2505
R1612 Vdd Vdd.n180 46.2505
R1613 Vdd.n182 Vdd 46.2505
R1614 Vdd Vdd.n159 46.2505
R1615 Vdd.n157 Vdd.n126 46.2505
R1616 Vdd.t24 Vdd.n157 46.2505
R1617 Vdd.n185 Vdd.n184 46.2505
R1618 Vdd.n184 Vdd.t10 46.2505
R1619 Vdd.n107 Vdd 46.2505
R1620 Vdd.t16 Vdd.n107 46.2505
R1621 Vdd Vdd.n113 46.2505
R1622 Vdd.n113 Vdd.t54 46.2505
R1623 Vdd.n115 Vdd 46.2505
R1624 Vdd.t14 Vdd.n115 46.2505
R1625 Vdd Vdd.n84 46.2505
R1626 Vdd.n84 Vdd.t28 46.2505
R1627 Vdd.n78 Vdd 46.2505
R1628 Vdd.t26 Vdd.n78 46.2505
R1629 Vdd Vdd.n76 46.2505
R1630 Vdd.n76 Vdd.t56 46.2505
R1631 Vdd.n74 Vdd.n73 46.2505
R1632 Vdd.n80 Vdd.n79 46.2505
R1633 Vdd.n79 Vdd.t26 46.2505
R1634 Vdd.n83 Vdd.n82 46.2505
R1635 Vdd.t28 Vdd.n83 46.2505
R1636 Vdd.n117 Vdd.n116 46.2505
R1637 Vdd.n116 Vdd.t14 46.2505
R1638 Vdd.n112 Vdd.n111 46.2505
R1639 Vdd.t54 Vdd.n112 46.2505
R1640 Vdd.n109 Vdd.n108 46.2505
R1641 Vdd.n108 Vdd.t16 46.2505
R1642 Vdd.n178 Vdd.n177 44.4416
R1643 Vdd.n168 Vdd.n167 44.4416
R1644 Vdd.n172 Vdd.n171 44.4416
R1645 Vdd.n180 Vdd.n179 44.4416
R1646 Vdd.n183 Vdd.n182 44.4416
R1647 Vdd.n159 Vdd.n158 44.4416
R1648 Vdd.n169 Vdd.n166 40.4696
R1649 Vdd.n221 Vdd.n220 39.1189
R1650 Vdd.n75 Vdd.n74 39.1189
R1651 Vdd.n307 Vdd.n306 38.212
R1652 Vdd.n316 Vdd.n301 38.212
R1653 Vdd.n283 Vdd.n282 38.212
R1654 Vdd.n295 Vdd.n278 38.212
R1655 Vdd.t20 Vdd.n302 35.6707
R1656 Vdd.t48 Vdd.n302 35.6707
R1657 Vdd.t18 Vdd.n279 35.6707
R1658 Vdd.t8 Vdd.n279 35.6707
R1659 Vdd.n24 Vdd.n23 32.9224
R1660 Vdd.n153 Vdd.n135 30.8357
R1661 Vdd.n148 Vdd.n147 30.8338
R1662 Vdd.n13 Vdd.n9 30.8338
R1663 Vdd.n35 Vdd.n34 30.8338
R1664 Vdd.n36 Vdd.n35 30.8338
R1665 Vdd.n23 Vdd.n22 30.8338
R1666 Vdd.n27 Vdd.n26 30.8338
R1667 Vdd.n27 Vdd.n18 30.8338
R1668 Vdd.n39 Vdd.n38 30.8338
R1669 Vdd.n17 Vdd.n3 30.8338
R1670 Vdd Vdd.t1 30.4001
R1671 Vdd Vdd.t43 30.4001
R1672 Vdd Vdd.t11 30.4001
R1673 Vdd Vdd.t25 30.4001
R1674 Vdd.n174 Vdd.n163 29.1348
R1675 Vdd.n175 Vdd.n174 28.6254
R1676 Vdd.n181 Vdd.n162 27.3351
R1677 Vdd.n161 Vdd.n128 26.8267
R1678 Vdd.n210 Vdd.n209 26.4291
R1679 Vdd.n209 Vdd.n207 26.4291
R1680 Vdd.n204 Vdd.n203 26.4291
R1681 Vdd.n203 Vdd.n199 26.4291
R1682 Vdd.n233 Vdd.n232 26.4291
R1683 Vdd.n232 Vdd.n200 26.4291
R1684 Vdd.n239 Vdd.n238 26.4291
R1685 Vdd.n238 Vdd.n236 26.4291
R1686 Vdd.n216 Vdd.n215 26.4291
R1687 Vdd.n215 Vdd.n213 26.4291
R1688 Vdd.n245 Vdd.n244 26.4291
R1689 Vdd.n244 Vdd.n242 26.4291
R1690 Vdd.n247 Vdd.n246 26.4291
R1691 Vdd.n218 Vdd.n217 26.4291
R1692 Vdd.n64 Vdd.n63 26.4291
R1693 Vdd.n63 Vdd.n61 26.4291
R1694 Vdd.n58 Vdd.n57 26.4291
R1695 Vdd.n57 Vdd.n53 26.4291
R1696 Vdd.n87 Vdd.n86 26.4291
R1697 Vdd.n86 Vdd.n54 26.4291
R1698 Vdd.n93 Vdd.n92 26.4291
R1699 Vdd.n92 Vdd.n90 26.4291
R1700 Vdd.n70 Vdd.n69 26.4291
R1701 Vdd.n69 Vdd.n67 26.4291
R1702 Vdd.n99 Vdd.n98 26.4291
R1703 Vdd.n98 Vdd.n96 26.4291
R1704 Vdd.n101 Vdd.n100 26.4291
R1705 Vdd.n72 Vdd.n71 26.4291
R1706 Vdd.n322 Vdd.n321 26.4291
R1707 Vdd.n326 Vdd.n325 26.4291
R1708 Vdd.n318 Vdd 26.212
R1709 Vdd Vdd.n297 23.0935
R1710 Vdd.n321 Vdd.n273 20.2995
R1711 Vdd.n321 Vdd.n320 20.2995
R1712 Vdd.n10 Vdd.n9 20.0448
R1713 Vdd.n142 Vdd.n141 18.5005
R1714 Vdd.n146 Vdd.n145 18.5005
R1715 Vdd.n140 Vdd.n137 14.2388
R1716 Vdd.n40 Vdd.n39 13.6024
R1717 Vdd.n12 Vdd.t38 12.865
R1718 Vdd.n21 Vdd.t44 12.865
R1719 Vdd.n151 Vdd.t34 12.865
R1720 Vdd.t34 Vdd.n150 12.865
R1721 Vdd.n37 Vdd.t50 12.865
R1722 Vdd.n30 Vdd.t12 12.865
R1723 Vdd.n141 Vdd.n140 12.8068
R1724 Vdd Vdd.t9 11.9347
R1725 Vdd Vdd.t19 11.9347
R1726 Vdd Vdd.t49 11.9347
R1727 Vdd Vdd.t21 11.9347
R1728 Vdd.n185 Vdd.n128 11.5728
R1729 Vdd.n176 Vdd.n128 11.5483
R1730 Vdd.n176 Vdd.n175 11.1866
R1731 Vdd.n175 Vdd.n166 11.1866
R1732 Vdd.n250 Vdd.t30 10.3649
R1733 Vdd.n104 Vdd.t6 10.3649
R1734 Vdd.t4 Vdd.n274 10.3649
R1735 Vdd.n323 Vdd.t4 10.3649
R1736 Vdd.n154 Vdd.n153 10.2288
R1737 Vdd.n147 Vdd.n136 8.37433
R1738 Vdd.n32 Vdd.n3 8.28635
R1739 Vdd.n170 Vdd.n169 7.4005
R1740 Vdd.n174 Vdd.n165 7.4005
R1741 Vdd.n174 Vdd.n173 7.4005
R1742 Vdd.n164 Vdd.n162 7.4005
R1743 Vdd.n161 Vdd.n130 7.4005
R1744 Vdd.n156 Vdd.n155 7.4005
R1745 Vdd.n132 Vdd.n127 7.4005
R1746 Vdd.n132 Vdd.n131 7.4005
R1747 Vdd.n219 Vdd.n211 7.34366
R1748 Vdd.n226 Vdd.n211 7.34366
R1749 Vdd.n227 Vdd.n226 7.34366
R1750 Vdd.n228 Vdd.n227 7.34366
R1751 Vdd.n228 Vdd.n195 7.34366
R1752 Vdd.n263 Vdd.n196 7.34366
R1753 Vdd.n257 Vdd.n196 7.34366
R1754 Vdd.n257 Vdd.n256 7.34366
R1755 Vdd.n256 Vdd.n255 7.34366
R1756 Vdd.n255 Vdd.n240 7.34366
R1757 Vdd.n73 Vdd.n65 7.34366
R1758 Vdd.n80 Vdd.n65 7.34366
R1759 Vdd.n81 Vdd.n80 7.34366
R1760 Vdd.n82 Vdd.n81 7.34366
R1761 Vdd.n82 Vdd.n49 7.34366
R1762 Vdd.n117 Vdd.n50 7.34366
R1763 Vdd.n111 Vdd.n50 7.34366
R1764 Vdd.n111 Vdd.n110 7.34366
R1765 Vdd.n110 Vdd.n109 7.34366
R1766 Vdd.n109 Vdd.n94 7.34366
R1767 Vdd.t32 Vdd.n143 7.02738
R1768 Vdd.n144 Vdd.t32 7.02738
R1769 Vdd.t22 Vdd.n221 6.16958
R1770 Vdd.t56 Vdd.n75 6.16958
R1771 Vdd.n186 Vdd.n185 6.09308
R1772 Vdd.n155 Vdd.n126 5.74375
R1773 Vdd.n248 Vdd.n240 5.32261
R1774 Vdd.n102 Vdd.n94 5.32261
R1775 Vdd.n10 Vdd.n8 5.15968
R1776 Vdd.n8 Vdd.n1 5.15968
R1777 Vdd.n25 Vdd.n2 5.15968
R1778 Vdd.n25 Vdd.n24 5.15968
R1779 Vdd.n264 Vdd.n195 5.01945
R1780 Vdd.n118 Vdd.n49 5.01945
R1781 Vdd.n40 Vdd.n1 4.60458
R1782 Vdd.n40 Vdd.n2 4.60458
R1783 Vdd.n320 Vdd 4.58607
R1784 Vdd.n154 Vdd.n134 4.4916
R1785 Vdd.n147 Vdd.n146 4.48648
R1786 Vdd.n189 Vdd 4.28806
R1787 Vdd.n187 Vdd.n186 4.0529
R1788 Vdd.n0 Vdd 3.43247
R1789 Vdd.n146 Vdd.n137 3.40985
R1790 Vdd.n155 Vdd.n154 3.32258
R1791 Vdd.n43 Vdd 3.26252
R1792 Vdd.n42 Vdd 3.26252
R1793 Vdd.n191 Vdd 3.24937
R1794 Vdd.n192 Vdd 3.24937
R1795 Vdd.n193 Vdd 3.24937
R1796 Vdd.n194 Vdd 3.24937
R1797 Vdd.n266 Vdd 3.24937
R1798 Vdd.n45 Vdd 3.24937
R1799 Vdd.n46 Vdd 3.24937
R1800 Vdd.n47 Vdd 3.24937
R1801 Vdd.n48 Vdd 3.24937
R1802 Vdd.n120 Vdd 3.24937
R1803 Vdd.n0 Vdd 3.22616
R1804 Vdd.n304 Vdd.n301 3.19016
R1805 Vdd.n306 Vdd.n305 3.19016
R1806 Vdd.n311 Vdd.n310 3.19016
R1807 Vdd.n310 Vdd.n302 3.19016
R1808 Vdd.n293 Vdd.n278 3.19016
R1809 Vdd.n282 Vdd.n281 3.19016
R1810 Vdd.n291 Vdd.n290 3.19016
R1811 Vdd.n290 Vdd.n279 3.19016
R1812 Vdd.n267 Vdd 3.15107
R1813 Vdd.n121 Vdd 3.15107
R1814 Vdd.n268 Vdd 3.13951
R1815 Vdd.n122 Vdd 3.13951
R1816 Vdd.n190 Vdd 2.93391
R1817 Vdd Vdd.n292 2.64071
R1818 Vdd.n327 Vdd.n326 2.63968
R1819 Vdd.n327 Vdd.n273 2.54071
R1820 Vdd.n137 Vdd.n134 2.5383
R1821 Vdd.n312 Vdd.n309 2.5222
R1822 Vdd.n264 Vdd.n263 2.32471
R1823 Vdd.n118 Vdd.n117 2.32471
R1824 Vdd.n187 Vdd.n126 2.04067
R1825 Vdd.n44 Vdd 1.98592
R1826 Vdd.n313 Vdd.n312 1.89975
R1827 Vdd.n292 Vdd.n289 1.78849
R1828 Vdd.n286 Vdd.n272 1.78432
R1829 Vdd.n287 Vdd.n272 1.56341
R1830 Vdd.n329 Vdd.n328 1.49842
R1831 Vdd.t0 Vdd.n167 1.28904
R1832 Vdd.n171 Vdd.t0 1.28904
R1833 Vdd.t42 Vdd.n178 1.28904
R1834 Vdd.n179 Vdd.t42 1.28904
R1835 Vdd.t10 Vdd.n183 1.28904
R1836 Vdd.n158 Vdd.t24 1.28904
R1837 Vdd.n288 Vdd.n287 1.1247
R1838 Vdd Vdd.n190 0.907483
R1839 Vdd.n41 Vdd.n40 0.857774
R1840 Vdd.n328 Vdd.n272 0.804721
R1841 Vdd.n269 Vdd.n122 0.777518
R1842 Vdd Vdd.n124 0.756538
R1843 Vdd.n285 Vdd 0.735748
R1844 Vdd.n314 Vdd.n313 0.622944
R1845 Vdd.n289 Vdd.n288 0.6205
R1846 Vdd.n326 Vdd 0.594314
R1847 Vdd.n271 Vdd 0.569741
R1848 Vdd.n125 Vdd.n123 0.544107
R1849 Vdd.n270 Vdd.n269 0.491946
R1850 Vdd.n329 Vdd.n271 0.47464
R1851 Vdd.n316 Vdd.t20 0.457864
R1852 Vdd.t48 Vdd.n307 0.457864
R1853 Vdd.t18 Vdd.n283 0.457864
R1854 Vdd.n295 Vdd.t8 0.457864
R1855 Vdd.n189 Vdd.n188 0.449786
R1856 Vdd.n124 Vdd 0.443357
R1857 Vdd.n124 Vdd 0.443357
R1858 Vdd.n123 Vdd 0.443357
R1859 Vdd.n123 Vdd 0.443357
R1860 Vdd.n122 Vdd.n121 0.395012
R1861 Vdd.n330 Vdd.n329 0.353038
R1862 Vdd.n48 Vdd.n47 0.268183
R1863 Vdd.n47 Vdd.n46 0.265744
R1864 Vdd.n121 Vdd.n120 0.265134
R1865 Vdd.n190 Vdd.n189 0.252643
R1866 Vdd.n265 Vdd.n264 0.233
R1867 Vdd.n119 Vdd.n118 0.233
R1868 Vdd.n43 Vdd.n42 0.206801
R1869 Vdd.n42 Vdd.n41 0.195622
R1870 Vdd.n46 Vdd.n45 0.193183
R1871 Vdd.n287 Vdd 0.175972
R1872 Vdd.n287 Vdd 0.175972
R1873 Vdd Vdd.n330 0.175972
R1874 Vdd.n330 Vdd 0.175972
R1875 Vdd Vdd.n298 0.173748
R1876 Vdd.n318 Vdd.n273 0.173748
R1877 Vdd.n320 Vdd 0.173748
R1878 Vdd.n297 Vdd.n276 0.173748
R1879 Vdd.n120 Vdd.n119 0.161476
R1880 Vdd.n286 Vdd.n285 0.1245
R1881 Vdd.n44 Vdd.n0 0.117878
R1882 Vdd.n289 Vdd.n285 0.117471
R1883 Vdd.n119 Vdd.n48 0.104159
R1884 Vdd.n313 Vdd.n271 0.103833
R1885 Vdd Vdd.n43 0.0792602
R1886 Vdd.n45 Vdd 0.0785488
R1887 Vdd.n270 Vdd.n44 0.0713333
R1888 Vdd.n162 Vdd.n161 0.0603131
R1889 Vdd.n39 Vdd.n3 0.0598968
R1890 Vdd.n268 Vdd.n267 0.0578989
R1891 Vdd.n188 Vdd.n125 0.0522857
R1892 Vdd.n269 Vdd.n268 0.0472275
R1893 Vdd.n194 Vdd.n193 0.0394461
R1894 Vdd.n193 Vdd.n192 0.0390912
R1895 Vdd.n267 Vdd.n266 0.0390025
R1896 Vdd.n188 Vdd.n187 0.0337143
R1897 Vdd.n328 Vdd 0.03175
R1898 Vdd.n125 Vdd 0.0287143
R1899 Vdd.n192 Vdd.n191 0.0285341
R1900 Vdd.n266 Vdd.n265 0.0239209
R1901 Vdd.n328 Vdd.n327 0.0163974
R1902 Vdd.n265 Vdd.n194 0.0155816
R1903 Vdd.n191 Vdd 0.0118556
R1904 Vdd.n44 Vdd.n41 0.00456504
R1905 Vdd Vdd.n270 0.00351581
R1906 Vdd.n288 Vdd.n286 0.00220233
R1907 x5.Phi_1 x5.Phi_1.t6 3310.71
R1908 x5.Phi_1 x5.Phi_1.t5 1898.45
R1909 x5.Phi_1 x5.Phi_1.t3 466.908
R1910 x5.Phi_1 x5.Phi_1.t4 331.947
R1911 x5.Phi_1 x5.Phi_1.t1 165.293
R1912 x5.Phi_1 x5.Phi_1.t0 165.293
R1913 x5.Phi_1 x5.Phi_1.t2 115.701
R1914 x5.Phi_1.n1 x5.Phi_1 15.3041
R1915 x5.Phi_1.n2 x5.Phi_1.n1 11.5999
R1916 x5.Phi_1.n3 x5.Phi_1 10.0797
R1917 x5.Phi_1.n4 x5.Phi_1 9.94762
R1918 x5.Phi_1.n3 x5.Phi_1 9.35313
R1919 x5.Phi_1.n0 x5.Phi_1 9.30425
R1920 x5.Phi_1.n1 x5.Phi_1.n0 9.21423
R1921 x5.Phi_1.n4 x5.Phi_1.n3 5.34194
R1922 x5.Phi_1.n6 x5.Phi_1.n5 4.81095
R1923 x5.Phi_1.n6 x5.Phi_1 2.3255
R1924 x5.Phi_1 x5.Phi_1.n6 2.3255
R1925 x5.Phi_1.n2 x5.Phi_1 2.31175
R1926 x5.Phi_1.n5 x5.Phi_1.n2 0.704092
R1927 x5.Phi_1.n5 x5.Phi_1.n4 0.414612
R1928 x5.Phi_1.n0 x5.Phi_1 0.057375
R1929 x5.Vplus.n6 x5.Vplus.t4 107.382
R1930 x5.Vplus.n2 x5.Vplus.t2 40.8142
R1931 x5.Vplus.n5 x5.Vplus.t1 40.8142
R1932 x5.Vplus.n0 x5.Vplus.t0 40.8142
R1933 x5.Vplus.n0 x5.Vplus 33.275
R1934 x5.Vplus.n2 x5.Vplus 33.275
R1935 x5.Vplus.n5 x5.Vplus 33.275
R1936 x5.Vplus x5.Vplus.t3 7.62538
R1937 x5.Vplus.n7 x5.Vplus.n6 4.90776
R1938 x5.Vplus.n9 x5.Vplus.n5 4.06685
R1939 x5.Vplus.n1 x5.Vplus.n0 2.69671
R1940 x5.Vplus.n3 x5.Vplus.n2 2.6715
R1941 x5.Vplus.n1 x5.Vplus 2.63554
R1942 x5.Vplus.n6 x5.Vplus 2.27033
R1943 x5.Vplus.n10 x5.Vplus.n9 1.5399
R1944 x5.Vplus.n9 x5.Vplus.n8 0.853
R1945 x5.Vplus x5.Vplus.t7 0.379389
R1946 x5.Vplus.n4 x5.Vplus 0.136374
R1947 x5.Vplus x5.Vplus.n10 0.118762
R1948 x5.Vplus.n11 x5.Vplus 0.104336
R1949 x5.Vplus x5.Vplus.n13 0.0960098
R1950 x5.Vplus x5.Vplus.t5 0.0952222
R1951 x5.Vplus.n13 x5.Vplus.n3 0.0914164
R1952 x5.Vplus.n12 x5.Vplus.n11 0.0892934
R1953 x5.Vplus.n13 x5.Vplus.n12 0.0746785
R1954 x5.Vplus.n12 x5.Vplus 0.0535312
R1955 x5.Vplus x5.Vplus.t14 0.0478611
R1956 x5.Vplus.n7 x5.Vplus 0.0475
R1957 x5.Vplus.n3 x5.Vplus.n1 0.0388248
R1958 x5.Vplus x5.Vplus.t10 0.0241806
R1959 x5.Vplus x5.Vplus.t6 0.0241806
R1960 x5.Vplus x5.Vplus.t8 0.0241806
R1961 x5.Vplus x5.Vplus.t13 0.0241806
R1962 x5.Vplus x5.Vplus.t9 0.0241806
R1963 x5.Vplus x5.Vplus.t11 0.0241806
R1964 x5.Vplus x5.Vplus.t12 0.0241806
R1965 x5.Vplus x5.Vplus.n4 0.0229898
R1966 x5.Vplus.n8 x5.Vplus.n7 0.0216758
R1967 x5.Vplus.n8 x5.Vplus 0.0216758
R1968 x5.Vplus.n11 x5.Vplus 0.0170269
R1969 x5.Vplus.n4 x5.Vplus 0.013302
R1970 x5.Vplus.n10 x5.Vplus 0.0118559
R1971 x1.XM3.D.n1 x1.XM3.D.t1 342.216
R1972 x1.XM3.D.t1 x1.XM3.D 337.565
R1973 x1.XM3.D.n0 x1.XM3.D.t3 168.181
R1974 x1.XM3.D x1.XM3.D.t2 30.4001
R1975 x1.XM3.D x1.XM3.D.t0 21.4587
R1976 x1.XM3.D.n2 x1.XM3.D 7.09715
R1977 x1.XM3.D.n1 x1.XM3.D.n0 4.05867
R1978 x1.XM3.D.n0 x1.XM3.D 3.48979
R1979 x1.XM3.D.n3 x1.XM3.D 2.26454
R1980 x1.XM3.D x1.XM3.D.n3 1.37898
R1981 x1.XM3.D.n3 x1.XM3.D.n2 0.212878
R1982 x1.XM3.D.n2 x1.XM3.D.n1 0.00285849
R1983 rst_rc rst_rc.t2 1898.45
R1984 rst_rc rst_rc.t0 1898.45
R1985 rst_rc rst_rc.t1 547.24
R1986 rst_rc rst_rc.t3 372.113
R1987 rst_rc.n0 rst_rc 11.7618
R1988 rst_rc.n0 rst_rc 11.49
R1989 rst_rc.n1 rst_rc.n0 10.6528
R1990 rst_rc.n1 rst_rc 9.34581
R1991 rst_rc rst_rc.n1 0.31925
R1992 Bit5 Bit5.t1 1898.45
R1993 Bit5 Bit5.t0 1898.45
R1994 Bit5.n0 Bit5 22.7249
R1995 Bit5.n1 Bit5 0.1055
R1996 Bit5 Bit5.n1 0.103441
R1997 Bit5.n0 Bit5 0.07675
R1998 Bit5 Bit5.n0 0.075995
R1999 Bit5.n1 Bit5 0.0488578
R2000 x5.XM13.D x5.sky130_fd_pr__cap_mim_m3_2_SLGBQV_8.C2.n0 14.3596
R2001 x5.XM13.D x5.sky130_fd_pr__cap_mim_m3_2_SLGBQV_8.C2.t0 7.62538
R2002 x5.sky130_fd_pr__cap_mim_m3_2_SLGBQV_8.C2.n0 x5.sky130_fd_pr__cap_mim_m3_2_SLGBQV_8.C2.t2 0.187359
R2003 x5.sky130_fd_pr__cap_mim_m3_2_SLGBQV_8.C2.n0 x5.sky130_fd_pr__cap_mim_m3_2_SLGBQV_8.C2.t1 0.18338
R2004 x5.Vminus.n0 x5.Vminus.t5 107.382
R2005 x5.Vminus.n6 x5.Vminus.t2 41.0016
R2006 x5.Vminus.n4 x5.Vminus 33.0976
R2007 x5.Vminus.n6 x5.Vminus 33.0976
R2008 x5.Vminus x5.Vminus.t0 7.62538
R2009 x5.Vminus x5.Vminus.n0 5.95593
R2010 x5.Vminus.n7 x5.Vminus.n6 2.75406
R2011 x5.Vminus.n5 x5.Vminus.n4 2.71332
R2012 x5.Vminus.n5 x5.Vminus 2.60571
R2013 x5.Vminus.n0 x5.Vminus 2.27033
R2014 x5.Vminus.n4 x5.Vminus.t1 1.50449
R2015 x5.Vminus.n1 x5.Vminus 0.585438
R2016 x5.Vminus x5.Vminus.t8 0.379389
R2017 x5.Vminus.n2 x5.Vminus.n1 0.213713
R2018 x5.Vminus.n3 x5.Vminus 0.155617
R2019 x5.Vminus x5.Vminus.n8 0.0999286
R2020 x5.Vminus x5.Vminus.t10 0.0952222
R2021 x5.Vminus x5.Vminus.n2 0.0853394
R2022 x5.Vminus.n8 x5.Vminus.n3 0.079289
R2023 x5.Vminus.n8 x5.Vminus.n7 0.0711587
R2024 x5.Vminus.n1 x5.Vminus 0.065232
R2025 x5.Vminus x5.Vminus.t6 0.0478611
R2026 x5.Vminus.n7 x5.Vminus.n5 0.0384302
R2027 x5.Vminus.n3 x5.Vminus 0.0348738
R2028 x5.Vminus x5.Vminus.t9 0.0241806
R2029 x5.Vminus x5.Vminus.t13 0.0241806
R2030 x5.Vminus x5.Vminus.t12 0.0241806
R2031 x5.Vminus x5.Vminus.t11 0.0241806
R2032 x5.Vminus x5.Vminus.t7 0.0241806
R2033 x5.Vminus x5.Vminus.t4 0.0241806
R2034 x5.Vminus x5.Vminus.t3 0.0241806
R2035 x5.Vminus.n2 x5.Vminus 0.0031997
R2036 x5.XC16.C2 x5.XC16.C2.t0 7.62538
R2037 x2.in x2.in.t2 707.908
R2038 x2.in x2.in.t7 547.24
R2039 x2.in x2.in.t5 452.447
R2040 x2.in x2.in.t4 372.113
R2041 x2.in x2.in.t1 165.293
R2042 x2.in x2.in.t6 160.833
R2043 x2.in x2.in.t3 125.808
R2044 x2.in x2.in.t0 115.701
R2045 x2.in.n8 x2.in.n7 10.0457
R2046 x2.in.n0 x2.in 9.70124
R2047 x2.in.n0 x2.in 9.6994
R2048 x2.in.n3 x2.in 9.66111
R2049 x2.in.n3 x2.in 9.64077
R2050 x2.in.n2 x2.in 7.0211
R2051 x2.in.n2 x2.in 7.01406
R2052 x2.in.n10 x2.in 5.96006
R2053 x2.in x2.in.n10 3.72966
R2054 x2.in.n7 x2.in.n2 1.98373
R2055 x2.in.n7 x2.in.n6 1.12855
R2056 x2.in.n5 x2.in 0.387219
R2057 x2.in.n1 x2.in.n0 0.339786
R2058 x2.in.n10 x2.in 0.223714
R2059 x2.in.n1 x2.in 0.194378
R2060 x2.in.n4 x2.in 0.0914926
R2061 x2.in.n4 x2.in 0.0855
R2062 x2.in.n6 x2.in.n5 0.06675
R2063 x2.in.n8 x2.in.n1 0.0358982
R2064 x2.in.n9 x2.in.n8 0.0358982
R2065 x2.in.n6 x2.in.n3 0.031125
R2066 x2.in x2.in.n9 0.0311122
R2067 x2.in.n5 x2.in.n4 0.0169871
R2068 x2.in.n9 x2.in 0.0137743
R2069 out out.t5 547.24
R2070 out out.t3 372.113
R2071 out out.t4 160.833
R2072 out out.t6 125.808
R2073 out out.t2 82.6472
R2074 out out.t1 57.8505
R2075 out.n7 out.t0 40.8142
R2076 out.n7 out 33.275
R2077 out.n2 out 9.66111
R2078 out.n2 out 9.64077
R2079 out.n1 out 7.0211
R2080 out.n1 out 7.01406
R2081 out.n0 out 4.55325
R2082 out.n8 out.n7 2.794
R2083 out.n9 out.n8 2.61621
R2084 out.n8 out.n6 2.5806
R2085 out.n0 out 2.19924
R2086 out.n6 out.n1 1.98678
R2087 out.n6 out.n5 1.1255
R2088 out.n4 out 0.387219
R2089 out out.n9 0.163256
R2090 out.n9 out.n0 0.113514
R2091 out.n3 out 0.0914926
R2092 out.n3 out 0.0855
R2093 out.n5 out.n4 0.06675
R2094 out.n5 out.n2 0.031125
R2095 out.n4 out.n3 0.0169871
R2096 Bit3 Bit3.t1 1898.45
R2097 Bit3 Bit3.t0 1898.45
R2098 Bit3.n0 Bit3 20.1615
R2099 Bit3 Bit3.n0 0.195812
R2100 Bit3.n1 Bit3 0.184324
R2101 Bit3.n1 Bit3 0.095197
R2102 Bit3 Bit3.n0 0.0924118
R2103 Bit3.n2 Bit3 0.060139
R2104 Bit3 Bit3.n2 0.0489883
R2105 Bit3.n2 Bit3.n1 0.0471319
R2106 x5.XC2.C2 x5.XC2.C2.t0 7.62538
R2107 x5.XM6.D x5.sky130_fd_pr__cap_mim_m3_2_SLGBQV_5.C2.t0 7.62538
R2108 x5.XM6.D x5.sky130_fd_pr__cap_mim_m3_2_SLGBQV_5.C2.t3 3.01719
R2109 x5.sky130_fd_pr__cap_mim_m3_2_SLGBQV_5.C2.t3 x5.sky130_fd_pr__cap_mim_m3_2_SLGBQV_5.C2.t2 0.175215
R2110 x5.sky130_fd_pr__cap_mim_m3_2_SLGBQV_5.C2.t3 x5.sky130_fd_pr__cap_mim_m3_2_SLGBQV_5.C2.t1 0.173538
R2111 Bit2 Bit2.t1 1898.45
R2112 Bit2 Bit2.t0 1898.45
R2113 x5.XC15.C2 x5.XC15.C2.t0 7.62538
R2114 x5.sky130_fd_pr__pfet_01v8_YRFZ7K_0.S.n0 x5.sky130_fd_pr__pfet_01v8_YRFZ7K_0.S.t0 40.8142
R2115 x5.sky130_fd_pr__pfet_01v8_YRFZ7K_0.S.n0 x5.sky130_fd_pr__pfet_01v8_YRFZ7K_0.S 33.275
R2116 x5.sky130_fd_pr__pfet_01v8_YRFZ7K_0.S x5.sky130_fd_pr__pfet_01v8_YRFZ7K_0.S.t2 11.9347
R2117 x5.sky130_fd_pr__pfet_01v8_YRFZ7K_0.S x5.sky130_fd_pr__pfet_01v8_YRFZ7K_0.S.t1 11.9347
R2118 x5.sky130_fd_pr__pfet_01v8_YRFZ7K_0.S x5.sky130_fd_pr__pfet_01v8_YRFZ7K_0.S.n1 3.42994
R2119 x5.sky130_fd_pr__pfet_01v8_YRFZ7K_0.S.n1 x5.sky130_fd_pr__pfet_01v8_YRFZ7K_0.S.n0 1.91883
R2120 x5.sky130_fd_pr__pfet_01v8_YRFZ7K_0.S.n1 x5.sky130_fd_pr__pfet_01v8_YRFZ7K_0.S 1.57484
R2121 x5.sky130_fd_pr__cap_mim_m3_2_SLGBQV_0.C2 x5.sky130_fd_pr__cap_mim_m3_2_SLGBQV_0.C2.t0 7.62538
R2122 x1.XM11.D.n0 x1.XM11.D.t3 167.76
R2123 x1.XM11.D.n1 x1.XM11.D.t1 167.504
R2124 x1.XM11.D x1.XM11.D.t0 58.6791
R2125 x1.XM11.D x1.XM11.D.t2 30.4001
R2126 x1.XM11.D.n2 x1.XM11.D.n0 4.9392
R2127 x1.XM11.D.n2 x1.XM11.D.n1 4.90414
R2128 x1.XM11.D.n1 x1.XM11.D 4.83752
R2129 x1.XM11.D.n0 x1.XM11.D 4.32955
R2130 x1.XM11.D.n3 x1.XM11.D 2.92674
R2131 x1.XM11.D x1.XM11.D.n3 1.10399
R2132 x1.XM11.D.n3 x1.XM11.D.n2 0.128934
R2133 x5.XC5.C2 x5.XC5.C2.t0 7.62538
R2134 x4.Rst x4.Rst.t3 466.908
R2135 x4.Rst x4.Rst.t4 331.947
R2136 x4.Rst x4.Rst.t2 111.784
R2137 x4.Rst x4.Rst.t1 111.784
R2138 x4.Rst x4.Rst.t0 79.0672
R2139 x4.Rst.n2 x4.Rst 12.9238
R2140 x4.Rst.n0 x4.Rst 9.7252
R2141 x4.Rst.n0 x4.Rst 9.3005
R2142 x4.Rst x4.Rst.n1 6.84561
R2143 x4.Rst.n3 x4.Rst 1.8605
R2144 x4.Rst x4.Rst.n3 1.8605
R2145 x4.Rst.n3 x4.Rst.n2 0.21103
R2146 x4.Rst.n2 x4.Rst 0.20425
R2147 x4.Rst.n1 x4.Rst.n0 0.099875
R2148 x4.Rst.n1 x4.Rst 0.061125
R2149 x5.XC1.C2 x5.XC1.C2.t0 7.62538
R2150 x5.sky130_fd_pr__res_xhigh_po_0p35_CBQ445_2.R2_2.n0 x5.sky130_fd_pr__res_xhigh_po_0p35_CBQ445_2.R2_2.t0 41.0016
R2151 x5.sky130_fd_pr__res_xhigh_po_0p35_CBQ445_2.R2_2.n0 x5.sky130_fd_pr__res_xhigh_po_0p35_CBQ445_2.R2_2 33.0976
R2152 x5.sky130_fd_pr__res_xhigh_po_0p35_CBQ445_2.R2_2 x5.sky130_fd_pr__res_xhigh_po_0p35_CBQ445_2.R2_2.t2 11.9347
R2153 x5.sky130_fd_pr__res_xhigh_po_0p35_CBQ445_2.R2_2 x5.sky130_fd_pr__res_xhigh_po_0p35_CBQ445_2.R2_2.t1 11.9347
R2154 x5.sky130_fd_pr__res_xhigh_po_0p35_CBQ445_2.R2_2 x5.sky130_fd_pr__res_xhigh_po_0p35_CBQ445_2.R2_2.n1 3.75826
R2155 x5.sky130_fd_pr__res_xhigh_po_0p35_CBQ445_2.R2_2.n1 x5.sky130_fd_pr__res_xhigh_po_0p35_CBQ445_2.R2_2.n0 1.88828
R2156 x5.sky130_fd_pr__res_xhigh_po_0p35_CBQ445_2.R2_2.n1 x5.sky130_fd_pr__res_xhigh_po_0p35_CBQ445_2.R2_2 1.82341
R2157 Bit1 Bit1.t0 1898.45
R2158 Bit1 Bit1.t1 1898.45
R2159 Bit1.n0 Bit1 23.3543
R2160 Bit1.n0 Bit1 0.123
R2161 Bit1 Bit1.n0 0.0605962
R2162 x5.XC13.C2 x5.XC13.C2.t0 7.62538
R2163 x5.XC14.C2 x5.XC14.C2.t0 7.62538
R2164 x5.XC3.C2 x5.XC3.C2.t0 7.62538
R2165 Bit0 Bit0.t1 1898.45
R2166 Bit0 Bit0.t0 1898.45
R2167 Bit0.n0 Bit0 0.225946
R2168 Bit0.n0 Bit0 0.218172
R2169 Bit0 Bit0.n0 0.00273214
R2170 Bit0.n0 Bit0 0.00265517
C0 x5.sky130_fd_pr__pfet_01v8_YRFZ7K_0.S x5.sky130_fd_pr__res_xhigh_po_0p35_CBQ445_3.R1_0 0.32539f
C1 Vdd x5.Phi_1 3.7352f
C2 x2.XM1.S x3.XM1.S 0.00255f
C3 Bit4 x5.XC5.C2 0.87331f
C4 x3.XM3.S x3.XM5.S 0.31219f
C5 x2.in x2.XM13.S 0.0265f
C6 Vdd x5.XM20.G 4.67854f
C7 x5.XC13.C2 x5.sky130_fd_pr__res_xhigh_po_0p35_CBQ445_1.R1_0 0.03624f
C8 x5.XM7.S x5.XC14.C2 1.70705f
C9 x5.Phi_1 x5.sky130_fd_pr__res_xhigh_po_0p35_CBQ445_3.R2_1 0.01287f
C10 x5.XC5.C2 x5.XC16.C2 0.57626f
C11 Bit1 x5.Vplus 0.12288f
C12 x5.sky130_fd_pr__pfet_01v8_YRFZ7K_0.S x5.Phi_2 0.60817f
C13 x5.sky130_fd_pr__cap_mim_m3_2_SLGBQV_2.C2 Bit5 0.47934f
C14 Bit2 x5.XC15.C2 0.58963f
C15 Vdd x1.XM4.S 1.94871f
C16 x5.Vminus x5.XC14.C2 10.3452f
C17 Vdd x2.XM3.S 0.97339f
C18 x3.XM13.S out 0.0265f
C19 x5.Phi_1 x5.XM8.S 0
C20 x5.XM15.S x5.XC13.C2 1.78888f
C21 x4.Set x3.XM13.S 0.2021f
C22 x5.sky130_fd_pr__cap_mim_m3_2_SLGBQV_2.C2 x5.sky130_fd_pr__cap_mim_m3_2_SLGBQV_0.C2 0.60006f
C23 Bit1 Bit2 0.00535f
C24 Bit0 x5.Phi_2 0.00421f
C25 x4.Rst x5.XC15.C2 0
C26 x2.in x2.XM1.S 0.67895f
C27 x5.Phi_1 x5.XM20.G 0.14205f
C28 Vdd x1.XM11.S 0.14396f
C29 Bit1 x5.XC2.C2 0.33017f
C30 rst_rc x5.sky130_fd_pr__res_xhigh_po_0p35_CBQ445_1.R2_1 0
C31 Bit0 x5.sky130_fd_pr__res_xhigh_po_0p35_CBQ445_0.R2_0 0.00164f
C32 Bit2 x5.XM11.S 0.00382f
C33 x2.in x3.XM5.S 0.00107f
C34 x4.Set out 0.94476f
C35 Bit0 x5.Vplus 0.11802f
C36 x4.XM6.S x4.Rst 0.01509f
C37 x5.XM15.S x5.sky130_fd_pr__res_xhigh_po_0p35_CBQ445_1.R1_0 0.00468f
C38 x5.Vplus Bit5 0.13107f
C39 x2.in x2.XM5.S 0.41333f
C40 x1.sky130_fd_pr__res_xhigh_po_0p35_T68YWU_0.R1_0 x5.Vplus 0.02141f
C41 x1.XM3.S x5.Vplus 0.59771f
C42 x5.Phi_2 x5.XM7.S 0.00292f
C43 Bit0 x5.XC2.C2 0.46933f
C44 x5.Vplus x5.sky130_fd_pr__cap_mim_m3_2_SLGBQV_0.C2 32.633f
C45 x5.Vminus x5.Phi_2 0.00249f
C46 x1.XM3.D x5.Vplus 0.83911f
C47 x1.XM3.S x1.XM9.G 1.19871f
C48 x5.sky130_fd_pr__res_xhigh_po_0p35_CBQ445_2.R1_1 rst_rc 0
C49 x2.XM1.S out 0
C50 x4.Rst x3.XM9.S 0.00143f
C51 x5.Vplus Bit3 0.12685f
C52 x5.sky130_fd_pr__res_xhigh_po_0p35_CBQ445_0.R2_2 x5.sky130_fd_pr__res_xhigh_po_0p35_CBQ445_0.R2_0 0.31166f
C53 x5.Vplus x5.XM13.S 0.00492f
C54 x1.XM3.D x1.XM9.G 0.46818f
C55 x3.XM5.S out 0.41279f
C56 x2.in x1.XM9.G 0.00215f
C57 Bit2 x5.sky130_fd_pr__cap_mim_m3_2_SLGBQV_0.C2 0.10333f
C58 x5.sky130_fd_pr__res_xhigh_po_0p35_CBQ445_1.R1_2 x5.XC13.C2 0.02897f
C59 x4.Set x3.XM5.S 0
C60 x5.sky130_fd_pr__res_xhigh_po_0p35_CBQ445_2.R1_1 x5.Vplus 0.36418f
C61 x5.Vminus rst_rc 0.11079f
C62 x2.XM9.S x4.Rst 0.62246f
C63 x5.XM8.S x5.XC15.C2 1.68228f
C64 Bit2 Bit3 0.00569f
C65 Vdd x4.sky130_fd_pr__nfet_01v8_3GJG22_1.D 0.00594f
C66 x5.Phi_1 x5.XC15.C2 0
C67 x5.XC15.C2 x5.XC16.C2 0.39565f
C68 x5.Vplus x1.XM11.D 0
C69 x2.in x4.Rst 1.01119f
C70 Bit1 x5.XM8.S 0.00198f
C71 x5.Vminus x5.Vplus 3.51504f
C72 Vdd x4.XM6.S 0.00457f
C73 x4.Set x5.Phi_2 0.95633f
C74 x5.Vplus x5.XC3.C2 17.8648f
C75 x5.Phi_2 x5.XC14.C2 0.00176f
C76 x1.XM9.G x1.XM11.D 1.18808f
C77 x5.Vminus x1.XM9.G 0.20084f
C78 Vdd x5.sky130_fd_pr__pfet_01v8_YRFZ7K_0.S 12.8349f
C79 x2.XM5.S out 0
C80 x5.XM8.S x5.XM11.S 0.00165f
C81 x5.Vminus Bit2 0.13552f
C82 x5.Phi_1 x4.sky130_fd_pr__nfet_01v8_3GJG22_1.D 0.14601f
C83 Bit2 x5.XC3.C2 0.7017f
C84 Bit0 x5.XC13.C2 0.26846f
C85 x5.XM11.S x5.XC16.C2 1.74834f
C86 x3.XM3.S Vdd 0.96927f
C87 x5.Phi_1 x4.XM6.S 0.02306f
C88 x5.sky130_fd_pr__res_xhigh_po_0p35_CBQ445_1.R1_2 x5.sky130_fd_pr__res_xhigh_po_0p35_CBQ445_1.R1_0 0.31454f
C89 x5.XC2.C2 x5.XC3.C2 0.52744f
C90 x5.XM12.S x5.XM13.S 0.00141f
C91 x5.Vplus out 0.57397f
C92 x2.XM9.S x2.XM7.S 0.32224f
C93 Vdd x3.XM1.S 1.1545f
C94 Vdd x3.XM9.S 0.95021f
C95 x5.sky130_fd_pr__pfet_01v8_YRFZ7K_0.S x5.Phi_1 0.21357f
C96 x1.XM9.G out 0.01172f
C97 x2.in x2.XM7.S 0.41086f
C98 x5.sky130_fd_pr__pfet_01v8_YRFZ7K_0.S x5.XM20.G 0.16015f
C99 x5.XC5.C2 Bit5 0.48489f
C100 x4.Set Bit2 0
C101 Vdd x2.XM9.S 0.95449f
C102 Vdd x1.XM3.S 0.02486f
C103 x5.Vminus x5.XM12.S 0.00201f
C104 Bit0 x5.XC1.C2 0.37377f
C105 x3.XM9.S x3.XM7.S 0.32224f
C106 Vdd x1.XM3.D 3.96106f
C107 x4.Set x4.Rst 0.82128f
C108 x2.in Vdd 2.2555f
C109 Bit4 Bit5 0.00276f
C110 x5.Phi_2 x5.sky130_fd_pr__res_xhigh_po_0p35_CBQ445_3.R1_0 0.00477f
C111 Bit0 x5.sky130_fd_pr__res_xhigh_po_0p35_CBQ445_1.R1_0 0.00166f
C112 x3.XM3.S x2.XM3.S 0.00255f
C113 x5.XC5.C2 x5.XM13.S 0.00494f
C114 x2.XM5.S x3.XM5.S 0.00255f
C115 Vdd x5.sky130_fd_pr__res_xhigh_po_0p35_CBQ445_2.R1_1 0.00268f
C116 Bit0 x5.XM15.S 0.05818f
C117 x5.sky130_fd_pr__cap_mim_m3_2_SLGBQV_2.C2 x5.Vplus 63.6875f
C118 x2.in x3.XM7.S 0.00106f
C119 x5.XC13.C2 x5.Vminus 6.09331f
C120 x2.XM13.S x4.Rst 0.2021f
C121 Vdd x1.XM11.D 4.32621f
C122 Bit4 x5.XM13.S 0.00126f
C123 x1.XM3.S x1.XM4.S 0.91973f
C124 Vdd x5.Vminus 0.0636f
C125 Bit3 x5.XC16.C2 0.63829f
C126 Bit1 x5.XC15.C2 0.74356f
C127 x5.Phi_2 rst_rc 0
C128 x5.Vminus x5.XC5.C2 63.8119f
C129 x1.XM3.D x1.XM4.S 0.87035f
C130 x5.Vminus x5.sky130_fd_pr__res_xhigh_po_0p35_CBQ445_3.R2_1 0.35963f
C131 Vdd x3.XM13.S 0.00124f
C132 x2.in x1.XM4.S 0.34189f
C133 out x2.XM7.S 0
C134 x5.Phi_1 x5.sky130_fd_pr__res_xhigh_po_0p35_CBQ445_2.R1_1 0.01392f
C135 x5.XM7.S x5.XM8.S 0.00291f
C136 x2.in x2.XM3.S 0.40835f
C137 x4.sky130_fd_pr__nfet_01v8_3GJG22_1.D x5.XC15.C2 0.00193f
C138 x5.sky130_fd_pr__res_xhigh_po_0p35_CBQ445_2.R1_1 x5.XM20.G 0.01413f
C139 x5.XC15.C2 x5.XM11.S 0
C140 x5.Vminus x5.XM8.S 0.00499f
C141 x2.XM1.S x4.Rst 0
C142 x1.XM3.S x1.XM11.S 0.00973f
C143 x5.XC1.C2 x5.sky130_fd_pr__res_xhigh_po_0p35_CBQ445_0.R2_2 0.00358f
C144 x5.Phi_1 x5.sky130_fd_pr__res_xhigh_po_0p35_CBQ445_0.R2_2 0.11821f
C145 Bit4 x5.Vminus 0.12148f
C146 x5.Phi_1 x5.Vminus 0.07818f
C147 x5.XC13.C2 x5.XC14.C2 0.39164f
C148 x1.XM3.D x1.XM11.S 0
C149 x5.Vminus x5.XC16.C2 32.5139f
C150 Vdd out 1.89779f
C151 x5.Vminus x5.XM20.G 0
C152 Vdd x4.Set 1.15298f
C153 x5.Vplus rst_rc 0.10639f
C154 x1.XM11.D x1.XM4.S 0
C155 x5.Vminus x1.XM4.S 0.64996f
C156 x5.XM15.S x5.XM7.S 0.00203f
C157 x4.Rst x5.Phi_2 0.13405f
C158 x3.XM7.S out 0.41062f
C159 x5.XM15.S x5.Vminus 0.00122f
C160 x4.Set x5.XM8.S 0
C161 x4.Set x3.XM7.S 0.00211f
C162 Vdd x2.XM13.S 0.00125f
C163 x1.XM11.D x1.XM11.S 0.49311f
C164 x5.Vminus x1.XM11.S 0.01915f
C165 x4.Set x5.Phi_1 0.2857f
C166 x5.Vplus x1.XM9.G 0.39509f
C167 x2.XM5.S x4.Rst 0
C168 x4.Set x5.XC16.C2 0.00165f
C169 Bit0 Bit1 0.00583f
C170 x5.Vplus Bit2 0.14325f
C171 x1.XM4.S out 0.00459f
C172 x2.XM3.S out 0
C173 x5.sky130_fd_pr__res_xhigh_po_0p35_CBQ445_1.R1_2 Bit0 0
C174 x5.Vplus x5.XC2.C2 10.4245f
C175 Vdd x2.XM1.S 1.15862f
C176 Bit3 x5.XC15.C2 0
C177 Vdd x3.XM5.S 0.96302f
C178 x5.XC13.C2 x5.Phi_2 0.00191f
C179 Bit4 x5.sky130_fd_pr__cap_mim_m3_2_SLGBQV_2.C2 0.75749f
C180 x2.XM5.S x2.XM7.S 0.34667f
C181 x5.XM7.S x5.XC15.C2 0.00646f
C182 Vdd x5.Phi_2 2.61903f
C183 x3.XM3.S x3.XM1.S 0.29788f
C184 x3.XM7.S x3.XM5.S 0.34667f
C185 x5.Vminus x5.XC15.C2 18.2329f
C186 Bit3 x5.XM11.S 0.0594f
C187 Bit1 x5.XM7.S 0.05503f
C188 x2.XM1.S x2.XM3.S 0.29788f
C189 Vdd x2.XM5.S 0.96714f
C190 x5.Phi_1 x5.sky130_fd_pr__res_xhigh_po_0p35_CBQ445_3.R1_0 0.00884f
C191 Bit1 x5.Vminus 0.09578f
C192 Vdd rst_rc 0.46862f
C193 Bit1 x5.XC3.C2 0.63494f
C194 x5.Phi_1 x5.Phi_2 4.66992f
C195 x5.sky130_fd_pr__res_xhigh_po_0p35_CBQ445_3.R2_1 rst_rc 0.01402f
C196 Vdd x5.Vplus 0.03753f
C197 x5.Phi_2 x5.XM20.G 0.04837f
C198 x5.Vminus x5.XM11.S 0.00179f
C199 x3.XM3.S x2.in 0.00107f
C200 x2.XM9.S x3.XM9.S 0.00255f
C201 x2.in x3.XM1.S 0.00127f
C202 x4.Set x5.XC15.C2 0.00123f
C203 x5.XC1.C2 x5.sky130_fd_pr__res_xhigh_po_0p35_CBQ445_0.R2_0 0.02343f
C204 x4.Rst x2.XM7.S 0.00211f
C205 x5.sky130_fd_pr__res_xhigh_po_0p35_CBQ445_1.R1_0 x5.Phi_2 0
C206 Vdd x1.XM9.G 1.92485f
C207 x5.XC14.C2 x5.XC15.C2 1.02571f
C208 x5.Phi_1 rst_rc 0.0453f
C209 x2.in x3.XM9.S 0
C210 x5.XM20.G rst_rc 0.8634f
C211 x4.Set Bit1 0
C212 x5.XM15.S x5.Phi_2 0.00298f
C213 Vdd x5.sky130_fd_pr__res_xhigh_po_0p35_CBQ445_2.R2_2 11.9613f
C214 Bit1 x5.XC14.C2 0.23249f
C215 x5.XM13.S Bit5 0.06115f
C216 Bit4 x5.Vplus 0.12129f
C217 x5.Vminus x5.sky130_fd_pr__res_xhigh_po_0p35_CBQ445_1.R2_1 0.45081f
C218 x2.in x2.XM9.S 0.41373f
C219 x1.XM3.S x1.XM3.D 0.11996f
C220 x5.Phi_1 x5.Vplus 0.08326f
C221 x2.XM5.S x2.XM3.S 0.31219f
C222 x5.Vplus x5.XC1.C2 5.99007f
C223 Bit0 x5.XM7.S 0.00315f
C224 x2.in x1.XM3.S 0
C225 Bit0 x5.sky130_fd_pr__res_xhigh_po_0p35_CBQ445_0.R2_2 0
C226 Vdd x4.Rst 2.38298f
C227 x4.Set x4.sky130_fd_pr__nfet_01v8_3GJG22_1.D 0.04925f
C228 x5.Vplus x5.XM20.G 0.00196f
C229 Bit0 x5.Vminus 0.11231f
C230 Bit2 x5.XM8.S 0.06142f
C231 Bit3 x5.sky130_fd_pr__cap_mim_m3_2_SLGBQV_0.C2 0.72534f
C232 x2.in x1.XM3.D 0
C233 x5.Vplus x1.XM4.S 0.00555f
C234 x4.Set x4.XM6.S 0.03034f
C235 x5.Phi_1 Bit2 0
C236 Bit2 x5.XC16.C2 0.08667f
C237 x4.Rst x5.XM8.S 0
C238 x5.Phi_1 x5.sky130_fd_pr__res_xhigh_po_0p35_CBQ445_2.R2_2 0.20501f
C239 x5.Vminus Bit5 0.12409f
C240 x1.XM9.G x1.XM4.S 0.07187f
C241 x5.sky130_fd_pr__res_xhigh_po_0p35_CBQ445_2.R2_0 x5.sky130_fd_pr__res_xhigh_po_0p35_CBQ445_2.R2_2 0.31418f
C242 x1.sky130_fd_pr__res_xhigh_po_0p35_T68YWU_0.R1_0 x5.Vminus 0.01706f
C243 x5.XC2.C2 x5.XC1.C2 0.66574f
C244 x3.XM13.S x3.XM9.S 0.02265f
C245 x5.sky130_fd_pr__res_xhigh_po_0p35_CBQ445_2.R2_2 x5.XM20.G 0.13707f
C246 x5.Phi_1 x4.Rst 0.05903f
C247 x1.XM3.S x5.Vminus 1.04063f
C248 x5.Vplus x1.XM11.S 0.00292f
C249 x3.XM3.S out 0.4074f
C250 x5.XM12.S x5.XC5.C2 1.69527f
C251 x1.XM3.D x1.XM11.D 0.00999f
C252 x5.sky130_fd_pr__cap_mim_m3_2_SLGBQV_0.C2 x5.XC3.C2 0.55784f
C253 x3.XM3.S x4.Set 0
C254 x5.Vminus x1.XM3.D 0.17736f
C255 x3.XM1.S out 0.67607f
C256 x2.in x5.Vminus 0.02417f
C257 x1.XM9.G x1.XM11.S 0.54678f
C258 Bit0 x5.XC14.C2 0.30098f
C259 x4.Set x3.XM1.S 0
C260 x4.Rst x2.XM3.S 0
C261 x5.Vminus Bit3 0.12171f
C262 x5.Vminus x5.XM13.S 0.00551f
C263 Vdd x2.XM7.S 0.96063f
C264 x3.XM9.S out 0.41373f
C265 Bit3 x5.XC3.C2 0
C266 x4.Set x3.XM9.S 0.62246f
C267 Bit4 x5.XM12.S 0.05987f
C268 x5.Phi_2 x5.XC15.C2 0
C269 x2.XM9.S out 0
C270 x1.XM3.S out 0.00282f
C271 x5.Vminus x5.XM7.S 0.00245f
C272 x3.XM7.S x2.XM7.S 0.00255f
C273 x5.Vminus x1.XM11.D 0.00292f
C274 Bit1 x5.Phi_2 0.00408f
C275 x2.in out 0.62441f
C276 x2.in x4.Set 0
C277 Vdd x5.sky130_fd_pr__res_xhigh_po_0p35_CBQ445_3.R2_1 0.00232f
C278 x5.sky130_fd_pr__res_xhigh_po_0p35_CBQ445_0.R1_1 rst_rc 0
C279 x5.sky130_fd_pr__res_xhigh_po_0p35_CBQ445_1.R1_2 x5.Phi_2 0.10097f
C280 x4.Set Bit3 0
C281 x4.sky130_fd_pr__nfet_01v8_3GJG22_1.D x5.Phi_2 0.02584f
C282 x2.XM13.S x2.XM9.S 0.02265f
C283 Vdd x3.XM7.S 0.95651f
C284 x4.XM6.S x5.Phi_2 0.15172f
C285 x5.Vplus x5.sky130_fd_pr__res_xhigh_po_0p35_CBQ445_0.R1_1 0.43908f
C286 rst_rc gnd 3.85614f
C287 Bit0 gnd 6.25864f
C288 Bit1 gnd 6.26642f
C289 Bit2 gnd 7.12035f
C290 Bit3 gnd 6.78576f
C291 Bit4 gnd 6.73734f
C292 Bit5 gnd 6.75115f
C293 out gnd 8.96378f
C294 Vdd gnd 0.15548p
C295 x5.sky130_fd_pr__res_xhigh_po_0p35_CBQ445_2.R2_2 gnd 7.19687f
C296 x5.sky130_fd_pr__res_xhigh_po_0p35_CBQ445_2.R1_1 gnd 0.60966f
C297 x5.sky130_fd_pr__res_xhigh_po_0p35_CBQ445_2.R2_0 gnd 0.63993f
C298 x5.sky130_fd_pr__res_xhigh_po_0p35_CBQ445_0.R2_2 gnd 4.06724f
C299 x5.sky130_fd_pr__res_xhigh_po_0p35_CBQ445_0.R1_1 gnd 0.57862f
C300 x5.sky130_fd_pr__res_xhigh_po_0p35_CBQ445_0.R2_0 gnd 0.61206f
C301 x5.XC1.C2 gnd 13.98544f
C302 x5.XC2.C2 gnd 18.19246f
C303 x5.XC3.C2 gnd 27.25626f
C304 x5.sky130_fd_pr__cap_mim_m3_2_SLGBQV_0.C2 gnd 44.45514f
C305 x5.sky130_fd_pr__cap_mim_m3_2_SLGBQV_2.C2 gnd 81.93433f
C306 x5.XM20.G gnd 2.19217f
C307 x5.sky130_fd_pr__pfet_01v8_YRFZ7K_0.S gnd 7.71364f
C308 x5.sky130_fd_pr__res_xhigh_po_0p35_CBQ445_3.R2_1 gnd 0.60528f
C309 x5.sky130_fd_pr__res_xhigh_po_0p35_CBQ445_3.R1_0 gnd 0.64186f
C310 x5.sky130_fd_pr__res_xhigh_po_0p35_CBQ445_1.R1_2 gnd 4.01669f
C311 x5.sky130_fd_pr__res_xhigh_po_0p35_CBQ445_1.R2_1 gnd 0.58857f
C312 x5.sky130_fd_pr__res_xhigh_po_0p35_CBQ445_1.R1_0 gnd 0.61728f
C313 x5.XC13.C2 gnd 11.87209f
C314 x5.XM15.S gnd 1.23702f
C315 x5.XC14.C2 gnd 15.85703f
C316 x5.XM7.S gnd 1.20373f
C317 x5.XC15.C2 gnd 24.85288f
C318 x5.XM8.S gnd 1.20039f
C319 x5.XC16.C2 gnd 41.99414f
C320 x5.XM11.S gnd 1.19696f
C321 x5.XC5.C2 gnd 80.46733f
C322 x5.XM12.S gnd 1.20081f
C323 x5.XM13.S gnd 1.19946f
C324 x4.sky130_fd_pr__nfet_01v8_3GJG22_1.D gnd 0.39864f
C325 x4.XM6.S gnd 0.39948f
C326 x3.XM13.S gnd 0.38195f
C327 x1.sky130_fd_pr__res_xhigh_po_0p35_T68YWU_0.R1_0 gnd 0.88545f
C328 x5.Phi_1 gnd 10.18298f
C329 x5.Phi_2 gnd 11.30099f
C330 x4.Set gnd 5.73176f
C331 x3.XM9.S gnd 0.95522f
C332 x3.XM7.S gnd 1.05973f
C333 x3.XM5.S gnd 1.06367f
C334 x3.XM3.S gnd 1.08022f
C335 x3.XM1.S gnd 1.18333f
C336 x2.XM13.S gnd 0.38195f
C337 x5.Vminus gnd 0.18826p
C338 x1.XM3.S gnd 2.40563f
C339 x5.Vplus gnd 0.17794p
C340 x4.Rst gnd 5.92471f
C341 x2.XM9.S gnd 0.95155f
C342 x2.XM7.S gnd 1.05606f
C343 x2.XM5.S gnd 1.06f
C344 x2.XM3.S gnd 1.07656f
C345 x2.XM1.S gnd 1.18f
C346 x2.in gnd 5.56496f
C347 x1.XM4.S gnd 1.71691f
C348 x1.XM3.D gnd 2.37083f
C349 x1.XM9.G gnd 5.42555f
C350 x1.XM11.D gnd 2.14848f
C351 x1.XM11.S gnd 4.71716f
C352 x5.XC3.C2.t0 gnd 0.12315f
C353 x5.XC14.C2.t0 gnd 0.11263f
C354 x5.XC13.C2.t0 gnd 0.093f
C355 x5.sky130_fd_pr__res_xhigh_po_0p35_CBQ445_2.R2_2.t2 gnd 0.99895f
C356 x5.sky130_fd_pr__res_xhigh_po_0p35_CBQ445_2.R2_2.t0 gnd 0.04152f
C357 x5.sky130_fd_pr__res_xhigh_po_0p35_CBQ445_2.R2_2.n0 gnd 0.46259f
C358 x5.sky130_fd_pr__res_xhigh_po_0p35_CBQ445_2.R2_2.n1 gnd 4.70725f
C359 x5.sky130_fd_pr__res_xhigh_po_0p35_CBQ445_2.R2_2.t1 gnd 0.99895f
C360 x5.XC1.C2.t0 gnd 0.08089f
C361 x4.Rst.t2 gnd 0.01842f
C362 x4.Rst.t0 gnd 0.0085f
C363 x4.Rst.t4 gnd 0.00507f
C364 x4.Rst.t3 gnd 0.00784f
C365 x4.Rst.n0 gnd 0.03677f
C366 x4.Rst.n1 gnd 0.9893f
C367 x4.Rst.n2 gnd 0.13276f
C368 x4.Rst.n3 gnd 0.09455f
C369 x4.Rst.t1 gnd 0.01842f
C370 x5.XC5.C2.t0 gnd 0.15157f
C371 x1.XM11.D.t0 gnd 0.04315f
C372 x1.XM11.D.t3 gnd 0.48193f
C373 x1.XM11.D.n0 gnd 0.0701f
C374 x1.XM11.D.t1 gnd 0.48193f
C375 x1.XM11.D.n2 gnd 1.17156f
C376 x1.XM11.D.n3 gnd 0.73402f
C377 x1.XM11.D.t2 gnd 0.24897f
C378 x5.sky130_fd_pr__cap_mim_m3_2_SLGBQV_0.C2.t0 gnd 0.14487f
C379 x5.sky130_fd_pr__pfet_01v8_YRFZ7K_0.S.t2 gnd 0.98327f
C380 x5.sky130_fd_pr__pfet_01v8_YRFZ7K_0.S.t0 gnd 0.0407f
C381 x5.sky130_fd_pr__pfet_01v8_YRFZ7K_0.S.n0 gnd 0.48634f
C382 x5.sky130_fd_pr__pfet_01v8_YRFZ7K_0.S.n1 gnd 4.93481f
C383 x5.sky130_fd_pr__pfet_01v8_YRFZ7K_0.S.t1 gnd 0.98327f
C384 x5.XC15.C2.t0 gnd 0.13917f
C385 x5.sky130_fd_pr__cap_mim_m3_2_SLGBQV_5.C2.t1 gnd 39.6305f
C386 x5.sky130_fd_pr__cap_mim_m3_2_SLGBQV_5.C2.t2 gnd 39.7777f
C387 x5.sky130_fd_pr__cap_mim_m3_2_SLGBQV_5.C2.t3 gnd 44.6524f
C388 x5.sky130_fd_pr__cap_mim_m3_2_SLGBQV_5.C2.t0 gnd 0.14744f
C389 x5.XM6.D gnd 8.09197f
C390 x5.XC2.C2.t0 gnd 0.10233f
C391 x2.in.t0 gnd 0.00671f
C392 x2.in.t2 gnd 0.01397f
C393 x2.in.t5 gnd 0.00801f
C394 x2.in.n0 gnd 0.04417f
C395 x2.in.n1 gnd 0.02516f
C396 x2.in.t6 gnd 0.05228f
C397 x2.in.t3 gnd 0.02972f
C398 x2.in.n2 gnd 0.25788f
C399 x2.in.t7 gnd 0.01004f
C400 x2.in.t4 gnd 0.00614f
C401 x2.in.n3 gnd 0.01977f
C402 x2.in.n4 gnd 0.02766f
C403 x2.in.n5 gnd 0.02456f
C404 x2.in.n6 gnd 0.0141f
C405 x2.in.n7 gnd 1.08862f
C406 x2.in.n8 gnd 0.49073f
C407 x2.in.n9 gnd 0.01009f
C408 x2.in.n10 gnd 0.07449f
C409 x2.in.t1 gnd 0.01443f
C410 x5.XC16.C2.t0 gnd 0.15669f
C411 x5.Vminus.t10 gnd 3.26166f
C412 x5.Vminus.t5 gnd 0.07804f
C413 x5.Vminus.n0 gnd 0.11301f
C414 x5.Vminus.t13 gnd 13.3269f
C415 x5.Vminus.t9 gnd 13.3269f
C416 x5.Vminus.t11 gnd 13.3269f
C417 x5.Vminus.t12 gnd 13.3269f
C418 x5.Vminus.n1 gnd 4.73342f
C419 x5.Vminus.n2 gnd 3.04541f
C420 x5.Vminus.t7 gnd 13.3269f
C421 x5.Vminus.t4 gnd 13.3269f
C422 x5.Vminus.t3 gnd 13.3269f
C423 x5.Vminus.t6 gnd 6.62525f
C424 x5.Vminus.n3 gnd 2.39615f
C425 x5.Vminus.t1 gnd 0.02569f
C426 x5.Vminus.n4 gnd 0.08977f
C427 x5.Vminus.t0 gnd 0.08659f
C428 x5.Vminus.n5 gnd 1.33277f
C429 x5.Vminus.t2 gnd 0.00713f
C430 x5.Vminus.n6 gnd 0.10529f
C431 x5.Vminus.n7 gnd 0.94639f
C432 x5.Vminus.n8 gnd 1.71531f
C433 x5.Vminus.t8 gnd 1.58496f
C434 x5.sky130_fd_pr__cap_mim_m3_2_SLGBQV_8.C2.t1 gnd 40.7082f
C435 x5.sky130_fd_pr__cap_mim_m3_2_SLGBQV_8.C2.n0 gnd 43.7493f
C436 x5.sky130_fd_pr__cap_mim_m3_2_SLGBQV_8.C2.t2 gnd 41.0913f
C437 x5.sky130_fd_pr__cap_mim_m3_2_SLGBQV_8.C2.t0 gnd 0.14817f
C438 x5.XM13.D gnd 6.70302f
C439 x1.XM3.D.t0 gnd 0.10053f
C440 x1.XM3.D.t3 gnd 0.42087f
C441 x1.XM3.D.n0 gnd 0.06813f
C442 x1.XM3.D.t1 gnd 0.42087f
C443 x1.XM3.D.n1 gnd 0.67899f
C444 x1.XM3.D.n2 gnd 0.32511f
C445 x1.XM3.D.n3 gnd 0.56101f
C446 x1.XM3.D.t2 gnd 0.21743f
C447 x5.Vplus.t0 gnd 0.00705f
C448 x5.Vplus.n0 gnd 0.12984f
C449 x5.Vplus.t3 gnd 0.08599f
C450 x5.Vplus.n1 gnd 1.34396f
C451 x5.Vplus.t2 gnd 0.00705f
C452 x5.Vplus.n2 gnd 0.10246f
C453 x5.Vplus.n3 gnd 1.04675f
C454 x5.Vplus.t14 gnd 6.57899f
C455 x5.Vplus.t10 gnd 13.2339f
C456 x5.Vplus.t6 gnd 13.2339f
C457 x5.Vplus.t8 gnd 13.2339f
C458 x5.Vplus.t13 gnd 13.2339f
C459 x5.Vplus.n4 gnd 8.93168f
C460 x5.Vplus.t1 gnd 0.00705f
C461 x5.Vplus.n5 gnd 0.14563f
C462 x5.Vplus.t4 gnd 0.0775f
C463 x5.Vplus.n6 gnd 0.10939f
C464 x5.Vplus.n7 gnd 0.45139f
C465 x5.Vplus.n8 gnd 0.01259f
C466 x5.Vplus.n9 gnd 2.14841f
C467 x5.Vplus.n10 gnd 5.91173f
C468 x5.Vplus.t9 gnd 13.2339f
C469 x5.Vplus.t11 gnd 13.2339f
C470 x5.Vplus.t12 gnd 13.2339f
C471 x5.Vplus.n11 gnd 5.02662f
C472 x5.Vplus.t5 gnd 3.23889f
C473 x5.Vplus.n12 gnd 2.69092f
C474 x5.Vplus.n13 gnd 1.44569f
C475 x5.Vplus.t7 gnd 1.5739f
C476 x5.Phi_1.t1 gnd 0.03224f
C477 x5.Phi_1.t6 gnd 0.17818f
C478 x5.Phi_1.t5 gnd 0.09868f
C479 x5.Phi_1.n0 gnd 0.14303f
C480 x5.Phi_1.n1 gnd 3.149f
C481 x5.Phi_1.n2 gnd 3.86317f
C482 x5.Phi_1.t3 gnd 0.01812f
C483 x5.Phi_1.t4 gnd 0.0117f
C484 x5.Phi_1.n3 gnd 0.0612f
C485 x5.Phi_1.t2 gnd 0.01499f
C486 x5.Phi_1.n4 gnd 0.17066f
C487 x5.Phi_1.n5 gnd 0.06891f
C488 x5.Phi_1.n6 gnd 0.18833f
C489 x5.Phi_1.t0 gnd 0.03224f
C490 Vdd.t21 gnd 0.01307f
C491 Vdd.t51 gnd 0.00103f
C492 Vdd.t39 gnd 0.00103f
C493 Vdd.n0 gnd 0.0153f
C494 Vdd.n1 gnd 0.00379f
C495 Vdd.n2 gnd 0.00379f
C496 Vdd.n3 gnd 0.00392f
C497 Vdd.n4 gnd 0
C498 Vdd.n5 gnd 0
C499 Vdd.t38 gnd 0.00752f
C500 Vdd.n6 gnd 0
C501 Vdd.n7 gnd 0
C502 Vdd.n8 gnd 0.0043f
C503 Vdd.n9 gnd 0.0145f
C504 Vdd.n10 gnd 0.01139f
C505 Vdd.n11 gnd 0
C506 Vdd.n13 gnd 0.00598f
C507 Vdd.n14 gnd 0
C508 Vdd.n15 gnd 0
C509 Vdd.n16 gnd 0
C510 Vdd.n17 gnd 0.00598f
C511 Vdd.n18 gnd 0.00683f
C512 Vdd.n19 gnd 0
C513 Vdd.n20 gnd 0
C514 Vdd.t44 gnd 0.00752f
C515 Vdd.n22 gnd 0.00598f
C516 Vdd.n23 gnd 0.00432f
C517 Vdd.n24 gnd 0.00887f
C518 Vdd.n25 gnd 0.0043f
C519 Vdd.n26 gnd 0
C520 Vdd.n27 gnd 0
C521 Vdd.n28 gnd 0
C522 Vdd.n29 gnd 0
C523 Vdd.t12 gnd 0.00752f
C524 Vdd.n31 gnd 0
C525 Vdd.n32 gnd 0.00468f
C526 Vdd.n33 gnd 0
C527 Vdd.n34 gnd 0
C528 Vdd.n35 gnd 0
C529 Vdd.n36 gnd 0.00683f
C530 Vdd.t50 gnd 0.00752f
C531 Vdd.n38 gnd 0.00598f
C532 Vdd.n39 gnd 0.00642f
C533 Vdd.n40 gnd 0.011f
C534 Vdd.n41 gnd 0.00755f
C535 Vdd.t45 gnd 0.00103f
C536 Vdd.t13 gnd 0.00103f
C537 Vdd.n42 gnd 0.00724f
C538 Vdd.n43 gnd 0.00542f
C539 Vdd.n44 gnd 0.00382f
C540 Vdd.t57 gnd 0.00136f
C541 Vdd.t27 gnd 0.00136f
C542 Vdd.t29 gnd 0.00136f
C543 Vdd.t15 gnd 0.00136f
C544 Vdd.t55 gnd 0.00136f
C545 Vdd.t17 gnd 0.00136f
C546 Vdd.t7 gnd 0.00136f
C547 Vdd.n45 gnd 0.00422f
C548 Vdd.n46 gnd 0.00626f
C549 Vdd.n47 gnd 0.00707f
C550 Vdd.n48 gnd 0.00531f
C551 Vdd.n49 gnd 0.00486f
C552 Vdd.n50 gnd 0.00571f
C553 Vdd.n51 gnd 0
C554 Vdd.n52 gnd 0
C555 Vdd.n53 gnd 0.01084f
C556 Vdd.n54 gnd 0.01084f
C557 Vdd.n55 gnd 0
C558 Vdd.n56 gnd 0
C559 Vdd.n57 gnd 0
C560 Vdd.n58 gnd 0
C561 Vdd.n59 gnd 0
C562 Vdd.n60 gnd 0
C563 Vdd.n61 gnd 0.01084f
C564 Vdd.n62 gnd 0
C565 Vdd.n63 gnd 0
C566 Vdd.n64 gnd 0
C567 Vdd.n65 gnd 0.00571f
C568 Vdd.n66 gnd 0
C569 Vdd.n67 gnd 0.01084f
C570 Vdd.n68 gnd 0
C571 Vdd.n69 gnd 0
C572 Vdd.n70 gnd 0
C573 Vdd.n71 gnd 0.00108f
C574 Vdd.n72 gnd 0.00854f
C575 Vdd.n73 gnd 0.00755f
C576 Vdd.n74 gnd 0
C577 Vdd.t56 gnd 0.01155f
C578 Vdd.n76 gnd 0
C579 Vdd.n77 gnd 0
C580 Vdd.n78 gnd 0
C581 Vdd.t26 gnd 0.01084f
C582 Vdd.n79 gnd 0
C583 Vdd.n80 gnd 0.00536f
C584 Vdd.n81 gnd 0.00571f
C585 Vdd.n82 gnd 0.00536f
C586 Vdd.n83 gnd 0
C587 Vdd.t28 gnd 0.01084f
C588 Vdd.n84 gnd 0
C589 Vdd.n85 gnd 0
C590 Vdd.n86 gnd 0
C591 Vdd.n87 gnd 0
C592 Vdd.n88 gnd 0
C593 Vdd.n89 gnd 0
C594 Vdd.n90 gnd 0.01084f
C595 Vdd.n91 gnd 0
C596 Vdd.n92 gnd 0
C597 Vdd.n93 gnd 0
C598 Vdd.n94 gnd 0.00497f
C599 Vdd.n95 gnd 0
C600 Vdd.n96 gnd 0.00934f
C601 Vdd.n97 gnd 0
C602 Vdd.n98 gnd 0
C603 Vdd.n99 gnd 0
C604 Vdd.n100 gnd 0
C605 Vdd.n101 gnd 0.00684f
C606 Vdd.n102 gnd 0.00637f
C607 Vdd.n103 gnd 0
C608 Vdd.t6 gnd 0.00864f
C609 Vdd.n105 gnd 0
C610 Vdd.n106 gnd 0
C611 Vdd.n107 gnd 0
C612 Vdd.t16 gnd 0.01084f
C613 Vdd.n108 gnd 0
C614 Vdd.n109 gnd 0.00536f
C615 Vdd.n110 gnd 0.00571f
C616 Vdd.n111 gnd 0.00536f
C617 Vdd.n112 gnd 0
C618 Vdd.t54 gnd 0.01084f
C619 Vdd.n113 gnd 0
C620 Vdd.n114 gnd 0
C621 Vdd.n115 gnd 0
C622 Vdd.t14 gnd 0.01084f
C623 Vdd.n116 gnd 0
C624 Vdd.n117 gnd 0.00353f
C625 Vdd.n118 gnd 0.00268f
C626 Vdd.n119 gnd 0.00288f
C627 Vdd.n120 gnd 0.00591f
C628 Vdd.n121 gnd 0.00856f
C629 Vdd.n122 gnd 0.02285f
C630 Vdd.t23 gnd 0.00136f
C631 Vdd.t3 gnd 0.00136f
C632 Vdd.t41 gnd 0.00136f
C633 Vdd.t37 gnd 0.00136f
C634 Vdd.t53 gnd 0.00136f
C635 Vdd.t47 gnd 0.00136f
C636 Vdd.t31 gnd 0.00136f
C637 Vdd.t33 gnd 0.00206f
C638 Vdd.t35 gnd 0.00103f
C639 Vdd.t25 gnd 0.0051f
C640 Vdd.t11 gnd 0.0051f
C641 Vdd.n123 gnd 0.02278f
C642 Vdd.t43 gnd 0.0051f
C643 Vdd.t1 gnd 0.0051f
C644 Vdd.n124 gnd 0.08609f
C645 Vdd.n125 gnd 0.00866f
C646 Vdd.n126 gnd 0.00415f
C647 Vdd.n127 gnd 0.00198f
C648 Vdd.n128 gnd 0.02478f
C649 Vdd.n129 gnd 0.00147f
C650 Vdd.n130 gnd 0.02148f
C651 Vdd.n131 gnd 0.02734f
C652 Vdd.n132 gnd 0.00198f
C653 Vdd.n133 gnd 0.00147f
C654 Vdd.n134 gnd 0.05319f
C655 Vdd.n135 gnd 0.00598f
C656 Vdd.n136 gnd 0.00463f
C657 Vdd.n137 gnd 0.08662f
C658 Vdd.n138 gnd 0.00131f
C659 Vdd.n139 gnd 0.00131f
C660 Vdd.n140 gnd 0.029f
C661 Vdd.n141 gnd 0.01695f
C662 Vdd.n142 gnd 0.00867f
C663 Vdd.t32 gnd 0.01166f
C664 Vdd.n145 gnd 0.00867f
C665 Vdd.n146 gnd 0.00366f
C666 Vdd.n147 gnd 0.00596f
C667 Vdd.n148 gnd 0.00598f
C668 Vdd.n149 gnd 0
C669 Vdd.t34 gnd 0.00821f
C670 Vdd.n152 gnd 0
C671 Vdd.n153 gnd 0.00893f
C672 Vdd.n154 gnd 0.08327f
C673 Vdd.n155 gnd 0.02993f
C674 Vdd.n156 gnd 0.02148f
C675 Vdd.n157 gnd 0.0015f
C676 Vdd.t24 gnd 0.02866f
C677 Vdd.n159 gnd 0.0015f
C678 Vdd.n160 gnd 0.00147f
C679 Vdd.n161 gnd 0.01245f
C680 Vdd.n162 gnd 0.01269f
C681 Vdd.n163 gnd 0.01277f
C682 Vdd.n164 gnd 0.02148f
C683 Vdd.n165 gnd 0.02148f
C684 Vdd.n166 gnd 0.02863f
C685 Vdd.n168 gnd 0.00252f
C686 Vdd.n169 gnd 0.03786f
C687 Vdd.n170 gnd 0.02148f
C688 Vdd.t0 gnd 0.02998f
C689 Vdd.n172 gnd 0.00252f
C690 Vdd.n173 gnd 0.02148f
C691 Vdd.n174 gnd 0.0236f
C692 Vdd.n175 gnd 0.02366f
C693 Vdd.n176 gnd 0.01216f
C694 Vdd.n177 gnd 0.00252f
C695 Vdd.t42 gnd 0.02998f
C696 Vdd.n180 gnd 0.00252f
C697 Vdd.n181 gnd 0.01358f
C698 Vdd.n182 gnd 0.0015f
C699 Vdd.t10 gnd 0.02866f
C700 Vdd.n184 gnd 0.0015f
C701 Vdd.n185 gnd 0.00938f
C702 Vdd.n186 gnd 0.00637f
C703 Vdd.n187 gnd 0.00323f
C704 Vdd.n188 gnd 0.01589f
C705 Vdd.n189 gnd 0.03087f
C706 Vdd.n190 gnd 0.1974f
C707 Vdd.n191 gnd 0.02152f
C708 Vdd.n192 gnd 0.03552f
C709 Vdd.n193 gnd 0.04113f
C710 Vdd.n194 gnd 0.02904f
C711 Vdd.n195 gnd 0.00486f
C712 Vdd.n196 gnd 0.00571f
C713 Vdd.n197 gnd 0
C714 Vdd.n198 gnd 0
C715 Vdd.n199 gnd 0.01084f
C716 Vdd.n200 gnd 0.01084f
C717 Vdd.n201 gnd 0
C718 Vdd.n202 gnd 0
C719 Vdd.n203 gnd 0
C720 Vdd.n204 gnd 0
C721 Vdd.n205 gnd 0
C722 Vdd.n206 gnd 0
C723 Vdd.n207 gnd 0.01084f
C724 Vdd.n208 gnd 0
C725 Vdd.n209 gnd 0
C726 Vdd.n210 gnd 0
C727 Vdd.n211 gnd 0.00571f
C728 Vdd.n212 gnd 0
C729 Vdd.n213 gnd 0.01084f
C730 Vdd.n214 gnd 0
C731 Vdd.n215 gnd 0
C732 Vdd.n216 gnd 0
C733 Vdd.n217 gnd 0.00108f
C734 Vdd.n218 gnd 0.00854f
C735 Vdd.n219 gnd 0.00755f
C736 Vdd.n220 gnd 0
C737 Vdd.t22 gnd 0.01155f
C738 Vdd.n222 gnd 0
C739 Vdd.n223 gnd 0
C740 Vdd.n224 gnd 0
C741 Vdd.t2 gnd 0.01084f
C742 Vdd.n225 gnd 0
C743 Vdd.n226 gnd 0.00536f
C744 Vdd.n227 gnd 0.00571f
C745 Vdd.n228 gnd 0.00536f
C746 Vdd.n229 gnd 0
C747 Vdd.t40 gnd 0.01084f
C748 Vdd.n230 gnd 0
C749 Vdd.n231 gnd 0
C750 Vdd.n232 gnd 0
C751 Vdd.n233 gnd 0
C752 Vdd.n234 gnd 0
C753 Vdd.n235 gnd 0
C754 Vdd.n236 gnd 0.01084f
C755 Vdd.n237 gnd 0
C756 Vdd.n238 gnd 0
C757 Vdd.n239 gnd 0
C758 Vdd.n240 gnd 0.00497f
C759 Vdd.n241 gnd 0
C760 Vdd.n242 gnd 0.00934f
C761 Vdd.n243 gnd 0
C762 Vdd.n244 gnd 0
C763 Vdd.n245 gnd 0
C764 Vdd.n246 gnd 0
C765 Vdd.n247 gnd 0.00684f
C766 Vdd.n248 gnd 0.00637f
C767 Vdd.n249 gnd 0
C768 Vdd.t30 gnd 0.00864f
C769 Vdd.n251 gnd 0
C770 Vdd.n252 gnd 0
C771 Vdd.n253 gnd 0
C772 Vdd.t46 gnd 0.01084f
C773 Vdd.n254 gnd 0
C774 Vdd.n255 gnd 0.00536f
C775 Vdd.n256 gnd 0.00571f
C776 Vdd.n257 gnd 0.00536f
C777 Vdd.n258 gnd 0
C778 Vdd.t52 gnd 0.01084f
C779 Vdd.n259 gnd 0
C780 Vdd.n260 gnd 0
C781 Vdd.n261 gnd 0
C782 Vdd.t36 gnd 0.01084f
C783 Vdd.n262 gnd 0
C784 Vdd.n263 gnd 0.00353f
C785 Vdd.n264 gnd 0.00268f
C786 Vdd.n265 gnd 0.01979f
C787 Vdd.n266 gnd 0.0331f
C788 Vdd.n267 gnd 0.05068f
C789 Vdd.n268 gnd 0.05618f
C790 Vdd.n269 gnd 0.57993f
C791 Vdd.n270 gnd 0.68981f
C792 Vdd.n271 gnd 0.93357f
C793 Vdd.n272 gnd 0.09112f
C794 Vdd.n273 gnd 0.00657f
C795 Vdd.t5 gnd 0.00136f
C796 Vdd.n275 gnd 0.00262f
C797 Vdd.n276 gnd 0.04624f
C798 Vdd.n277 gnd 0.00259f
C799 Vdd.n278 gnd 0.03783f
C800 Vdd.n279 gnd 0.04303f
C801 Vdd.n280 gnd 0.00259f
C802 Vdd.n281 gnd 0.06684f
C803 Vdd.n282 gnd 0.03783f
C804 Vdd.t18 gnd 0.04598f
C805 Vdd.n284 gnd 0.00262f
C806 Vdd.n285 gnd 0.00126f
C807 Vdd.n286 gnd 0.06375f
C808 Vdd.t19 gnd 0.01307f
C809 Vdd.t9 gnd 0.01307f
C810 Vdd.n287 gnd 0.04854f
C811 Vdd.n288 gnd 0.03304f
C812 Vdd.n289 gnd 0.00283f
C813 Vdd.n290 gnd 0.00448f
C814 Vdd.n291 gnd 0.00448f
C815 Vdd.n292 gnd 0.00881f
C816 Vdd.n293 gnd 0.02566f
C817 Vdd.n294 gnd 0.00262f
C818 Vdd.t8 gnd 0.04598f
C819 Vdd.n296 gnd 0.00262f
C820 Vdd.n297 gnd 0.09279f
C821 Vdd.n298 gnd 0.04624f
C822 Vdd.n299 gnd 0.00262f
C823 Vdd.n300 gnd 0.00259f
C824 Vdd.n301 gnd 0.03783f
C825 Vdd.n302 gnd 0.04303f
C826 Vdd.n303 gnd 0.00259f
C827 Vdd.n304 gnd 0.06327f
C828 Vdd.n305 gnd 0.02871f
C829 Vdd.n306 gnd 0.03783f
C830 Vdd.t48 gnd 0.04598f
C831 Vdd.n308 gnd 0.00262f
C832 Vdd.n309 gnd 0.03557f
C833 Vdd.n310 gnd 0.00448f
C834 Vdd.n311 gnd 0.00448f
C835 Vdd.n312 gnd 0.00943f
C836 Vdd.n313 gnd 0.0041f
C837 Vdd.n314 gnd 0.05628f
C838 Vdd.n315 gnd 0.00262f
C839 Vdd.t20 gnd 0.04598f
C840 Vdd.n317 gnd 0.00262f
C841 Vdd.n318 gnd 0.10523f
C842 Vdd.n319 gnd 0.00109f
C843 Vdd.n320 gnd 0.00968f
C844 Vdd.n321 gnd 0.00402f
C845 Vdd.n322 gnd 0.00684f
C846 Vdd.t4 gnd 0.00942f
C847 Vdd.n324 gnd 0.00109f
C848 Vdd.n325 gnd 0.00684f
C849 Vdd.n326 gnd 0.00492f
C850 Vdd.n327 gnd 0.00789f
C851 Vdd.n328 gnd 0.08973f
C852 Vdd.n329 gnd 0.06399f
C853 Vdd.t49 gnd 0.01307f
C854 Vdd.n330 gnd 0.04597f
C855 x5.Phi_2.t2 gnd 0.03499f
C856 x5.Phi_2.t5 gnd 0.19334f
C857 x5.Phi_2.t4 gnd 0.10708f
C858 x5.Phi_2.n0 gnd 1.68779f
C859 x5.Phi_2.n1 gnd 1.59575f
C860 x5.Phi_2.t3 gnd 0.01966f
C861 x5.Phi_2.t6 gnd 0.0127f
C862 x5.Phi_2.n2 gnd 0.06148f
C863 x5.Phi_2.n3 gnd 0.10281f
C864 x5.Phi_2.t0 gnd 0.01627f
C865 x5.Phi_2.n4 gnd 0.12966f
C866 x5.Phi_2.n5 gnd 0.23598f
C867 x5.Phi_2.t1 gnd 0.03499f
C868 x5.sky130_fd_pr__cap_mim_m3_2_SLGBQV_2.C2.t0 gnd 0.15234f
.ends
